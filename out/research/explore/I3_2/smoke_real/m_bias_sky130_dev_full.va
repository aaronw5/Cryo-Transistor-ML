`include "disciplines.vams"
`include "constants.vams"
// I3-2 multiplicative correction (M_bias), 1-member 3-16-...-1 tanh MLP ensemble.
// I(d->s) total = I_sim * exp(g); g = mean over members of tanh(h(x)),
// x = standardized [pmos, abs(V(g, s)) / VDD, abs(V(d, s)) / VDD].
// abs() maps pMOS and nMOS forward bias to the same range; reverse-mode
// bias (Vds of the opposite sign) is folded onto forward mode.
module i3_2_bias_corr(d, g, s, di);
  inout d, g, s, di;
  electrical d, g, s, di;
  branch (d, di) sense;   // I(sense) = drain current into the compact model
  parameter real L = 1.0;   // um
  parameter real W = 1.0;   // um
  parameter real pmos = 0;  // 0 nMOS, 1 pMOS
  parameter real VDD = 1.85;
  real ib, gsum, acc, x0, x1, x2;
  real h0, h1, h2, h3, h4, h5, h6, h7, h8, h9, h10, h11, h12, h13, h14, h15;
  real k0, k1, k2, k3, k4, k5, k6, k7, k8, k9, k10, k11, k12, k13, k14, k15;
  analog begin
    V(sense) <+ 0.0;
    ib = I(sense);
    x0 = (pmos - 0.0000000000e+00) / 1.0000000000e+00;
    x1 = (abs(V(g, s)) / VDD - 6.8648907885e-01) / 2.3178751205e-01;
    x2 = (abs(V(d, s)) / VDD - 5.1463795190e-01) / 3.1747276139e-01;
    gsum = 0.0;
    // ensemble member 0
    h0 = tanh(-2.7092575756e-01 + -7.9478549432e-02 * x0 + 2.8860243645e-01 * x1 + -6.6111358720e-01 * x2);
    h1 = tanh(9.5514190070e-02 + -2.6890967036e-01 * x0 + -1.2169716822e-01 * x1 + 3.6308150876e-02 * x2);
    h2 = tanh(3.5942267065e-01 + 1.8419241189e-01 * x0 + 3.8708034324e-01 * x1 + 2.3479338242e-01 * x2);
    h3 = tanh(5.7728344248e-01 + 1.1129939913e-02 * x0 + -2.1475161107e-01 * x1 + -1.9309909500e-01 * x2);
    h4 = tanh(1.3063158165e-01 + -4.6755205615e-01 * x0 + -3.5794972858e-01 * x1 + -1.5845841170e-01 * x2);
    h5 = tanh(1.0194299318e-01 + -2.6969445288e-02 * x0 + 9.3373462134e-02 * x1 + 2.1008739437e-01 * x2);
    h6 = tanh(5.6876355340e-01 + -2.9260729425e-01 * x0 + -1.6753090371e-01 * x1 + 2.7680483520e-01 * x2);
    h7 = tanh(-2.5540674995e-01 + 4.5089553562e-01 * x0 + 2.0414596152e-02 * x1 + 4.8993789501e-01 * x2);
    h8 = tanh(1.5117512378e-01 + -1.3869470677e-01 * x0 + 3.9612950160e-02 * x1 + 7.5705642369e-01 * x2);
    h9 = tanh(-3.4862569759e-01 + -4.4566168431e-01 * x0 + -2.1558352863e-01 * x1 + -2.5005760230e-01 * x2);
    h10 = tanh(-5.8720585960e-01 + -9.4904508455e-02 * x0 + 3.6835684855e-01 * x1 + -3.5781213996e-01 * x2);
    h11 = tanh(-3.8791354327e-01 + -5.2238414672e-01 * x0 + -2.9904389192e-01 * x1 + -1.0458794484e+00 * x2);
    h12 = tanh(4.3523996878e-01 + -2.5586265501e-01 * x0 + 1.8846672448e-01 * x1 + 3.5168876651e-01 * x2);
    h13 = tanh(2.2775582962e-01 + 4.0074739591e-01 * x0 + 1.4611839392e-01 * x1 + -4.1277231882e-01 * x2);
    h14 = tanh(-5.4176368463e-01 + 1.5265352749e-01 * x0 + -2.3448995186e-01 * x1 + -5.2183105833e-01 * x2);
    h15 = tanh(2.3226811338e-01 + -2.7122695582e-01 * x0 + 2.2940628908e-01 * x1 + 2.5261322350e-01 * x2);
    k0 = tanh(5.1144737797e-02 + 2.6348346567e-02 * h0 + -8.1151758124e-02 * h1 + 4.9877444766e-02 * h2 + 9.0134257248e-02 * h3 + 3.4113600538e-02 * h4 + 1.3245191731e-01 * h5 + -2.5669777280e-01 * h6 + -1.2505163588e-01 * h7 + 1.3072426343e-01 * h8 + 9.8680217281e-02 * h9 + 2.3177940404e-01 * h10 + 2.2949672180e-01 * h11 + 1.0714611653e-02 * h12 + -1.8487755705e-01 * h13 + 3.4994193819e-02 * h14 + -1.4040653071e-01 * h15);
    k1 = tanh(3.9044421268e-02 + -1.2478083329e-01 * h0 + 6.7605927122e-02 * h1 + 1.5037654902e-01 * h2 + -8.0746801789e-02 * h3 + -1.4086057800e-03 * h4 + -7.4735545448e-02 * h5 + -1.8377807685e-01 * h6 + -1.6931092456e-01 * h7 + 7.3683513972e-02 * h8 + -1.5153136471e-01 * h9 + 1.3696465276e-01 * h10 + 1.5568112480e-01 * h11 + 6.3976977183e-02 * h12 + -5.4754779719e-02 * h13 + -1.4639217241e-01 * h14 + -1.7284819634e-01 * h15);
    k2 = tanh(-1.9939241871e-01 + 1.9011837690e-01 * h0 + 5.0926265371e-02 * h1 + -1.8637138173e-01 * h2 + -1.5362406861e-01 * h3 + 2.3376503840e-01 * h4 + 1.6718049210e-01 * h5 + 8.0037939780e-02 * h6 + 1.6340321276e-02 * h7 + -2.9393426350e-01 * h8 + 3.7411162284e-02 * h9 + -2.2513733540e-01 * h10 + -2.1237063149e-01 * h11 + 2.3409287185e-02 * h12 + 2.2848527989e-01 * h13 + -1.0548674831e-01 * h14 + 1.5816418111e-01 * h15);
    k3 = tanh(5.8613005745e-02 + -1.4538589044e-01 * h0 + 9.0505900847e-02 * h1 + 1.7800379532e-01 * h2 + -7.7245018470e-02 * h3 + -1.0267090640e-01 * h4 + -2.3130023882e-03 * h5 + -9.6966437588e-02 * h6 + -3.0330587206e-02 * h7 + 1.1590441244e-01 * h8 + -4.9116245415e-02 * h9 + -5.4213667602e-02 * h10 + 1.1989553836e-01 * h11 + -1.9937361583e-01 * h12 + -1.2036357045e-01 * h13 + -5.2080036454e-02 * h14 + -1.0670885294e-01 * h15);
    k4 = tanh(1.7202530584e-01 + -1.3827238183e-01 * h0 + -1.2146370253e-01 * h1 + -4.1690531754e-02 * h2 + 7.2701553178e-02 * h3 + -1.2975927785e-01 * h4 + -3.9714438922e-02 * h5 + -1.2319195321e-03 * h6 + -8.3052407101e-02 * h7 + 7.5930528977e-02 * h8 + -3.7012336314e-02 * h9 + 9.5107472570e-02 * h10 + 1.8176989538e-01 * h11 + 1.6082473456e-01 * h12 + -7.9583956476e-02 * h13 + 2.2333746878e-01 * h14 + -4.2059469844e-02 * h15);
    k5 = tanh(2.1424485486e-01 + -7.7987535218e-02 * h0 + -5.7835291635e-02 * h1 + 1.0379626530e-01 * h2 + 3.7731701709e-02 * h3 + -7.7536814840e-02 * h4 + -1.0991099762e-01 * h5 + -1.2306602412e-01 * h6 + -9.4535870937e-02 * h7 + -3.0653051937e-02 * h8 + 7.3222146507e-02 * h9 + 8.8114533677e-02 * h10 + -1.1672919496e-01 * h11 + 4.8727373932e-02 * h12 + -8.9565941379e-02 * h13 + -4.2602285219e-03 * h14 + -8.7178391143e-02 * h15);
    k6 = tanh(1.0459558464e-01 + 1.6647261758e-02 * h0 + 3.8449406174e-02 * h1 + -2.1228760483e-01 * h2 + -1.9819734813e-01 * h3 + 4.2414100333e-02 * h4 + 1.2510802445e-02 * h5 + 1.2901914829e-01 * h6 + 1.2104634715e-01 * h7 + -1.8656650996e-01 * h8 + 5.8761472226e-02 * h9 + 6.6964933657e-02 * h10 + -1.0158890926e-01 * h11 + 1.6889492155e-01 * h12 + 1.1438422941e-01 * h13 + -1.7234165570e-01 * h14 + 1.2640525163e-01 * h15);
    k7 = tanh(6.1660938302e-03 + 1.8003277760e-02 * h0 + -1.4164624332e-02 * h1 + 1.2653414257e-01 * h2 + -2.3045678491e-01 * h3 + 6.3741913005e-02 * h4 + 6.0376065479e-04 * h5 + 2.2880290342e-01 * h6 + 1.6883261938e-01 * h7 + 3.4879982264e-02 * h8 + 1.2576293798e-01 * h9 + -1.0379360162e-01 * h10 + -6.6978371128e-02 * h11 + -1.1907056028e-01 * h12 + 1.4004511875e-01 * h13 + 1.5084521651e-01 * h14 + 1.7705417004e-01 * h15);
    k8 = tanh(1.0265916529e-01 + -3.0432770273e-02 * h0 + 3.9801504059e-02 * h1 + -1.7298722357e-01 * h2 + -1.4321495021e-01 * h3 + -6.2165206986e-02 * h4 + 8.5660075732e-02 * h5 + 8.1376868213e-02 * h6 + 5.7674702200e-02 * h7 + -9.3498643515e-02 * h8 + 1.8770018327e-01 * h9 + -2.1971278912e-01 * h10 + -1.9483257787e-01 * h11 + -9.0308100362e-02 * h12 + 2.6713334774e-01 * h13 + -9.2268844653e-02 * h14 + 1.9347140170e-01 * h15);
    k9 = tanh(-1.3644432181e-01 + 6.2301768047e-02 * h0 + 8.3315195850e-02 * h1 + -2.9556142249e-02 * h2 + -9.4098829980e-02 * h3 + 8.4720582252e-02 * h4 + -1.0554957704e-02 * h5 + 1.9077995734e-01 * h6 + 1.2488534546e-01 * h7 + -1.6768165482e-01 * h8 + -6.1032390652e-02 * h9 + 6.8024516583e-02 * h10 + -2.2826742068e-01 * h11 + 2.0789753826e-02 * h12 + 2.0467955935e-01 * h13 + 5.0976950557e-02 * h14 + 4.6266314439e-02 * h15);
    k10 = tanh(-3.6523731901e-02 + -5.8713967242e-01 * h0 + 1.3612989721e-01 * h1 + -4.4303719407e-02 * h2 + 1.1015236328e-01 * h3 + -1.1724639922e-01 * h4 + 1.4622351832e-01 * h5 + 3.9768889661e-01 * h6 + 4.1905167093e-01 * h7 + 3.4364138333e-01 * h8 + 7.6766546048e-02 * h9 + -1.8105310080e-01 * h10 + -3.8499797958e-01 * h11 + 2.8654448056e-01 * h12 + -9.7054942423e-02 * h13 + -3.3573083003e-01 * h14 + 2.7973589539e-01 * h15);
    k11 = tanh(-2.1911135827e-01 + 1.0681865222e-01 * h0 + 1.4469592050e-01 * h1 + -8.5956003495e-02 * h2 + -3.1449542229e-02 * h3 + 1.4691295389e-01 * h4 + -1.5877031134e-01 * h5 + 2.2965301371e-01 * h6 + -3.9414822821e-02 * h7 + -6.5362929933e-02 * h8 + 9.4561772499e-03 * h9 + -1.5697322523e-01 * h10 + 8.9376029620e-05 * h11 + 1.8240900401e-01 * h12 + 1.1875837556e-01 * h13 + -1.2896916598e-01 * h14 + -4.4182754232e-02 * h15);
    k12 = tanh(2.2949801449e-01 + -6.8560943523e-02 * h0 + 1.2069331485e-01 * h1 + -1.2393264033e-01 * h2 + -9.9367730824e-02 * h3 + 2.2211766486e-02 * h4 + 7.5981595859e-02 * h5 + 1.9290331499e-01 * h6 + 6.3509531290e-02 * h7 + -9.2380376004e-03 * h8 + 1.1016925940e-02 * h9 + -1.1912185292e-01 * h10 + 7.3133716016e-03 * h11 + 1.3174533766e-01 * h12 + 5.0866140396e-02 * h13 + -9.0204411263e-02 * h14 + -3.1949514893e-02 * h15);
    k13 = tanh(1.3421788185e-01 + -1.0194245449e-01 * h0 + 6.3339159894e-02 * h1 + -1.1990107623e-01 * h2 + -1.5130275966e-01 * h3 + 1.6173267137e-01 * h4 + -7.6418913117e-02 * h5 + 4.8943755489e-02 * h6 + 5.5862941797e-02 * h7 + 3.1021576424e-03 * h8 + -7.9550012251e-02 * h9 + -1.1366997719e-01 * h10 + 1.2700510012e-01 * h11 + 2.5472806418e-02 * h12 + 7.8993365263e-02 * h13 + -5.4028749541e-02 * h14 + 4.6189197106e-02 * h15);
    k14 = tanh(-1.9823298073e-01 + 3.7300428350e-03 * h0 + 2.5973648341e-02 * h1 + -1.6377041112e-01 * h2 + 1.1818109544e-02 * h3 + 1.0229998104e-01 * h4 + 1.3432869501e-02 * h5 + 1.1177999470e-01 * h6 + -5.1691064527e-03 * h7 + 9.2938996011e-02 * h8 + -1.1387349281e-01 * h9 + 2.1567740451e-02 * h10 + -1.1027662047e-01 * h11 + -8.7130087390e-02 * h12 + 1.3833984815e-01 * h13 + -1.2198571345e-01 * h14 + 6.6092260121e-02 * h15);
    k15 = tanh(9.9015484892e-02 + -8.8454719004e-02 * h0 + -1.5608450736e-01 * h1 + 4.5793878354e-02 * h2 + 1.2941988625e-01 * h3 + 5.3482517379e-02 * h4 + -5.4356326299e-02 * h5 + -2.8729507068e-01 * h6 + -7.9280770876e-02 * h7 + 2.0584416780e-01 * h8 + -1.2093708823e-01 * h9 + 1.6069078519e-01 * h10 + 1.9335164780e-01 * h11 + -1.5262014342e-01 * h12 + -2.5137800051e-01 * h13 + 1.0702778918e-01 * h14 + -1.4010080113e-02 * h15);
    acc = -2.0031719488e-02 + -4.6132730907e-02 * k0 + -8.1949667002e-02 * k1 + 1.3409240319e-01 * k2 + -5.1946129058e-02 * k3 + -7.8984581848e-02 * k4 + -1.9257141873e-02 * k5 + 5.9330629468e-02 * k6 + 1.5809609122e-01 * k7 + 7.5675411937e-02 * k8 + 1.1485714065e-01 * k9 + -1.0548836202e-01 * k10 + 5.7840051144e-02 * k11 + 2.1325467374e-02 * k12 + 1.9258395308e-02 * k13 + 1.5284488148e-01 * k14 + -2.6208636748e-01 * k15;
    gsum = gsum + 1 * tanh(acc);
    I(d, s) <+ (exp(gsum / 1) - 1.0) * ib;
  end
endmodule

// Netlist use (one transistor):
//   M1 di g s b <compact-model card> L=.. W=..
//   YCORR d g s di i3_2_bias_corr L=.. W=.. pmos=..
