`include "disciplines.vams"
`include "constants.vams"
// E1 multiplicative correction, 5-member MLP ensemble.
// I(d->s) total = I_bsim * exp(g(phi)); phi = [pmos, |Vgs|/VDD, |Vds|/VDD,
// log10 L, log10 W, log10(|I_bsim| L / W + 1e-13)] standardized.
module e1_corr(d, g, s, di);
  inout d, g, s, di;
  electrical d, g, s, di;
  branch (d, di) sense;   // I(sense) = drain current into the BSIM4 drain
  parameter real L = 1.0;   // um
  parameter real W = 1.0;   // um
  parameter real pmos = 0;  // 0 nMOS, 1 pMOS
  parameter real VDD = 1.85;
  real ib, gsum, x0, x1, x2, x3, x4, x5, acc;
  real h0, h1, h2, h3, h4, h5, h6, h7, h8, h9, h10, h11, h12, h13, h14, h15, h16, h17, h18, h19, h20, h21, h22, h23, h24, h25, h26, h27, h28, h29, h30, h31;
  real k0, k1, k2, k3, k4, k5, k6, k7, k8, k9, k10, k11, k12, k13, k14, k15, k16, k17, k18, k19, k20, k21, k22, k23, k24, k25, k26, k27, k28, k29, k30, k31;
  analog begin
    V(sense) <+ 0.0;
    ib = I(sense);
    x0 = (pmos - 0.0000000000e+00) / 1.0000000000e+00;
    x1 = (abs(V(g, s)) / VDD - 6.8648907885e-01) / 2.3178751205e-01;
    x2 = (abs(V(d, s)) / VDD - 5.1463795190e-01) / 3.1747276139e-01;
    x3 = (log(L) - 2.9266920273e-01) / 8.7823886689e-01;
    x4 = (log(W) - 4.1171885896e-01) / 6.5950728139e-01;
    x5 = (log(abs(ib) * L / W + 1e-13) - -5.2087789095e+00) / 1.7220797012e+00;
    gsum = 0.0;
    // ensemble member 0
    h0 = tanh(-3.4412786133e-01 + 9.0371882284e-02 * x0 + 2.7225213818e-01 * x1 + -3.2771780915e-01 * x2 + -1.3067011902e-01 * x3 + -8.1457267383e-02 * x4 + 1.5635480038e-01 * x5);
    h1 = tanh(-5.6069813480e-02 + -5.2481275367e-02 * x0 + 2.3328873675e-01 * x1 + -4.6824860191e-02 * x2 + 5.4691955480e-02 * x3 + -1.2552841298e-01 * x4 + -6.9215557978e-02 * x5);
    h2 = tanh(-2.3337913533e-01 + -5.6534180261e-01 * x0 + -1.8184593708e-01 * x1 + -5.9765847032e-01 * x2 + 2.3195619510e-01 * x3 + -1.9532632193e-01 * x4 + 2.4141007609e-01 * x5);
    h3 = tanh(-2.2695714154e-01 + -2.9042058315e-01 * x0 + -1.0850715170e-01 * x1 + -1.3233366034e-02 * x2 + 7.1982959374e-02 * x3 + -2.5742420695e-02 * x4 + 7.0990582419e-01 * x5);
    h4 = tanh(-1.8169994636e-01 + 5.3754142733e-02 * x0 + 2.4044619617e-02 * x1 + 5.1995850890e-01 * x2 + -2.7918527346e-01 * x3 + 9.2554148335e-02 * x4 + -1.7463150937e-01 * x5);
    h5 = tanh(1.2692296508e-01 + -2.3954688465e-01 * x0 + 3.0847779048e-01 * x1 + -2.9634953086e-01 * x2 + -7.6961583159e-02 * x3 + -1.5999233991e-01 * x4 + -4.7234270385e-01 * x5);
    h6 = tanh(-2.3917838833e-01 + -2.0090699712e-01 * x0 + 3.3790734773e-01 * x1 + 5.4374678596e-02 * x2 + 4.8980649322e-02 * x3 + -1.0894032906e-01 * x4 + -2.5690204420e-01 * x5);
    h7 = tanh(-5.2102660638e-02 + -1.2118355398e-01 * x0 + -1.8926417879e-01 * x1 + -2.4744798716e-01 * x2 + 3.0973081527e-02 * x3 + 1.1091700537e-01 * x4 + 3.1834896179e-01 * x5);
    h8 = tanh(3.0563480849e-02 + -1.4265572823e-01 * x0 + -1.3143220375e-02 * x1 + 1.6226176210e-01 * x2 + 2.5297419367e-01 * x3 + -1.6553678410e-02 * x4 + -5.7405096661e-02 * x5);
    h9 = tanh(1.8694922719e-01 + 2.9566616263e-01 * x0 + -3.3155381124e-01 * x1 + 1.1465541220e-01 * x2 + 1.9996651075e-01 * x3 + -1.7081789722e-02 * x4 + -3.8578854052e-01 * x5);
    h10 = tanh(-2.9340342081e-01 + 1.6088958510e-01 * x0 + 2.1399059274e-01 * x1 + -1.5953142191e-01 * x2 + 3.8474037773e-02 * x3 + -5.4481737378e-02 * x4 + 5.2023549768e-02 * x5);
    h11 = tanh(6.1372571317e-02 + 4.0749620452e-01 * x0 + 1.1321007668e-01 * x1 + 3.3547495504e-01 * x2 + 4.7793153053e-02 * x3 + -1.6385969736e-02 * x4 + -3.4960165737e-01 * x5);
    h12 = tanh(-2.2115238263e-01 + 2.9104976938e-01 * x0 + 3.9556891062e-01 * x1 + 3.9282351760e-01 * x2 + 3.8672719491e-03 * x3 + 5.2341809101e-02 * x4 + -3.4223582306e-01 * x5);
    h13 = tanh(2.4615770472e-01 + -1.3142355338e-02 * x0 + -3.7119750386e-01 * x1 + -2.7787188857e-01 * x2 + 3.6796406985e-01 * x3 + 1.0782361990e-01 * x4 + -4.3301807599e-01 * x5);
    h14 = tanh(1.3375862379e-01 + 3.6789971729e-01 * x0 + 5.1551642812e-02 * x1 + 2.6896416749e-01 * x2 + -1.8446318912e-01 * x3 + 7.1458010199e-02 * x4 + -2.9887104631e-01 * x5);
    h15 = tanh(2.6870174044e-01 + 3.6113584932e-02 * x0 + 1.1958702225e-01 * x1 + 3.0419961983e-01 * x2 + 2.5959275436e-01 * x3 + -3.6435079910e-01 * x4 + -2.2980582561e-01 * x5);
    h16 = tanh(6.5136112576e-02 + 7.1719868271e-02 * x0 + -4.0073518323e-02 * x1 + -3.8887865302e-01 * x2 + -1.6341733433e-01 * x3 + 6.5294628754e-02 * x4 + 2.1084853567e-01 * x5);
    h17 = tanh(-1.5550984033e-01 + -7.3520716392e-01 * x0 + -7.1386800353e-02 * x1 + -5.2340071525e-01 * x2 + 4.8418034112e-02 * x3 + 4.8030154945e-02 * x4 + -5.5051923466e-01 * x5);
    h18 = tanh(3.1313370417e-02 + -8.8623018201e-02 * x0 + 2.5408518414e-02 * x1 + -1.3210833863e-01 * x2 + 2.1559490688e-01 * x3 + -2.7190277440e-01 * x4 + 5.2825096700e-01 * x5);
    h19 = tanh(-1.0779174908e-02 + 3.3210576204e-01 * x0 + -2.9803771663e-01 * x1 + 6.9976772624e-02 * x2 + -2.6581579793e-02 * x3 + 1.5997719748e-01 * x4 + 1.2793763989e-01 * x5);
    h20 = tanh(2.5895951724e-04 + 1.2678312247e-01 * x0 + -1.2194988462e-02 * x1 + -2.7348049952e-02 * x2 + 2.3317699600e-01 * x3 + -1.7918071177e-01 * x4 + -2.0268815235e-01 * x5);
    h21 = tanh(-5.8735607574e-02 + -6.6164015358e-02 * x0 + -1.9004160910e-01 * x1 + -1.8664863279e-02 * x2 + -1.0264607275e-01 * x3 + 1.2544372727e-01 * x4 + 1.0740506574e-01 * x5);
    h22 = tanh(5.1991624098e-02 + -2.7464057698e-01 * x0 + 6.2257262289e-02 * x1 + 3.7948938379e-01 * x2 + 1.3548520735e-01 * x3 + 6.3470225572e-02 * x4 + -9.4786119370e-03 * x5);
    h23 = tanh(4.8167996826e-02 + 1.7072195674e-02 * x0 + 1.7364430671e-01 * x1 + 2.7279805373e-01 * x2 + 2.9484409642e-01 * x3 + 1.3622630832e-01 * x4 + -8.2702302914e-02 * x5);
    h24 = tanh(-2.3081617294e-01 + -3.4605448440e-01 * x0 + -2.0588673611e-01 * x1 + 5.6215704188e-02 * x2 + 1.2306675242e-01 * x3 + 1.4512667938e-01 * x4 + -2.6344775267e-01 * x5);
    h25 = tanh(-1.8133273543e-01 + 4.3374159379e-02 * x0 + -1.7408806827e-01 * x1 + -2.6310919920e-02 * x2 + 1.1060780144e-01 * x3 + 1.9821675719e-02 * x4 + -7.6055236526e-01 * x5);
    h26 = tanh(3.2380198411e-01 + 2.2093864252e-01 * x0 + -2.9959246018e-01 * x1 + -1.7278248127e-01 * x2 + -4.9024929553e-02 * x3 + -1.7293681165e-02 * x4 + -3.5060032247e-02 * x5);
    h27 = tanh(-2.7121794531e-01 + -3.1663130682e-01 * x0 + -4.6880829503e-01 * x1 + -1.4500657392e-01 * x2 + 9.1122746650e-02 * x3 + -4.6968856222e-02 * x4 + -6.0676885624e-02 * x5);
    h28 = tanh(8.3530230472e-02 + -2.7977815629e-01 * x0 + -4.7092562429e-02 * x1 + 2.9901048012e-01 * x2 + -3.5936229995e-02 * x3 + -3.9276322848e-02 * x4 + 6.7567156815e-01 * x5);
    h29 = tanh(3.6401341350e-01 + -4.9097321613e-01 * x0 + 2.1912914260e-01 * x1 + -1.7968983057e-02 * x2 + -1.1321496114e-01 * x3 + 3.2497517776e-01 * x4 + -3.7721801045e-01 * x5);
    h30 = tanh(2.0983238041e-01 + 1.2457023146e-01 * x0 + -8.9100947281e-02 * x1 + 1.8060094008e-01 * x2 + 9.3885508975e-02 * x3 + 5.7379530068e-02 * x4 + 1.1732337086e-01 * x5);
    h31 = tanh(6.9622723346e-02 + -6.4903932931e-02 * x0 + -9.3126541820e-02 * x1 + -2.7328699338e-01 * x2 + 8.2706990413e-02 * x3 + 3.3707668921e-01 * x4 + 2.3952993169e-01 * x5);
    k0 = tanh(1.5902268790e-01 + 7.3974603871e-03 * h0 + 3.9965471475e-02 * h1 + -1.0518248491e-01 * h2 + 5.8866805111e-02 * h3 + -2.6974968986e-02 * h4 + -1.4839808073e-01 * h5 + 1.2012434514e-02 * h6 + 6.9449814420e-02 * h7 + -1.4433983606e-02 * h8 + 1.2361357898e-01 * h9 + 7.1488646975e-02 * h10 + -4.0818559651e-02 * h11 + 7.5199002386e-02 * h12 + -6.5926377984e-03 * h13 + -8.7977848474e-03 * h14 + 5.2690641998e-02 * h15 + -1.2204132034e-02 * h16 + 1.5827601827e-01 * h17 + -1.2123532318e-01 * h18 + -8.4194894075e-03 * h19 + 3.8591692832e-02 * h20 + -1.0434710837e-01 * h21 + -6.6305915306e-02 * h22 + -1.1419498152e-01 * h23 + -2.0267083204e-02 * h24 + 2.1561812576e-02 * h25 + 6.6829450886e-02 * h26 + -3.3707402435e-02 * h27 + 2.3324249320e-01 * h28 + 4.6576246214e-02 * h29 + -8.9238240444e-02 * h30 + -4.5249028907e-02 * h31);
    k1 = tanh(-1.5231453266e-02 + 5.9403662889e-03 * h0 + 8.9013546678e-02 * h1 + -8.6741103188e-02 * h2 + 5.8365947133e-03 * h3 + -5.8832469474e-02 * h4 + -6.4763003727e-02 * h5 + 9.7762945535e-02 * h6 + 6.8972879221e-02 * h7 + -3.4146584337e-02 * h8 + 3.2299340024e-02 * h9 + 4.1445507553e-02 * h10 + -7.6647253282e-03 * h11 + 1.4327481944e-01 * h12 + 9.9960945666e-02 * h13 + -2.5281101464e-02 * h14 + -4.3971061448e-02 * h15 + -7.4606357081e-02 * h16 + 9.3221241957e-02 * h17 + -1.5547365887e-01 * h18 + -1.1139387991e-01 * h19 + 9.3668680911e-02 * h20 + -1.0165597046e-01 * h21 + -1.2097207120e-01 * h22 + 1.8210980317e-02 * h23 + -2.9634927564e-02 * h24 + -7.1890803834e-02 * h25 + 2.8865742719e-02 * h26 + 6.2984337081e-02 * h27 + 1.7872421643e-01 * h28 + 1.8558968538e-01 * h29 + -8.5034709806e-02 * h30 + -5.7677560543e-02 * h31);
    k2 = tanh(6.4657440291e-02 + -9.7570286859e-02 * h0 + -4.5573955860e-02 * h1 + -4.5635761284e-02 * h2 + -2.4803133537e-02 * h3 + 1.2306144272e-02 * h4 + 9.4225505925e-02 * h5 + -3.7343054934e-02 * h6 + -3.6949162527e-02 * h7 + 5.2936445690e-02 * h8 + -8.6892690065e-02 * h9 + -1.6035493623e-02 * h10 + 4.0196242359e-03 * h11 + -8.3318664192e-02 * h12 + -3.1810782490e-02 * h13 + -4.6720163106e-02 * h14 + -7.6859176484e-03 * h15 + 3.0413787155e-02 * h16 + -1.4691618291e-01 * h17 + 1.0039878360e-01 * h18 + 3.9169186628e-02 * h19 + 2.6590456697e-02 * h20 + 1.9216240664e-02 * h21 + 6.3541282529e-02 * h22 + -9.5106094325e-03 * h23 + 8.9354630085e-02 * h24 + -6.7682696170e-02 * h25 + -4.2665859613e-02 * h26 + 1.6267226793e-01 * h27 + -1.7801288421e-01 * h28 + -9.2983649322e-02 * h29 + 6.7034814316e-02 * h30 + 4.1615894366e-02 * h31);
    k3 = tanh(1.7900824406e-01 + 5.8749534951e-02 * h0 + 7.0438761288e-03 * h1 + -9.2299271255e-02 * h2 + 1.1677513188e-01 * h3 + -4.0738676253e-02 * h4 + -1.3898236812e-01 * h5 + 3.3287067850e-02 * h6 + 3.5291604791e-02 * h7 + 2.0933099856e-02 * h8 + 7.6414554891e-02 * h9 + -2.2588588376e-02 * h10 + -4.3982564900e-02 * h11 + 5.7086704470e-02 * h12 + 1.6286603286e-01 * h13 + -1.5567587429e-02 * h14 + 4.2259011690e-02 * h15 + 5.3783526020e-04 * h16 + 2.0367996665e-01 * h17 + -4.0783394770e-02 * h18 + 3.3074115016e-02 * h19 + -1.2323372322e-02 * h20 + -2.6815125059e-02 * h21 + -7.4927296423e-02 * h22 + 3.5044980071e-02 * h23 + -7.9347771877e-02 * h24 + 1.8177873205e-01 * h25 + 1.2195699066e-01 * h26 + 2.6922384450e-02 * h27 + 6.3887746455e-02 * h28 + 1.8527217009e-01 * h29 + -5.7475094758e-02 * h30 + 4.3658454713e-02 * h31);
    k4 = tanh(1.1299595066e-01 + 6.4696785449e-03 * h0 + 8.7211059025e-04 * h1 + 5.0039878365e-03 * h2 + 6.2826707379e-05 * h3 + -3.1412859742e-03 * h4 + 2.8900633492e-03 * h5 + 6.0420921088e-03 * h6 + 6.6645347600e-03 * h7 + -8.3297258552e-04 * h8 + 4.6289921089e-03 * h9 + 4.2101030507e-03 * h10 + -8.3170601580e-03 * h11 + -8.3689438328e-03 * h12 + 2.1217113694e-02 * h13 + -7.6566969167e-03 * h14 + -1.5144717409e-02 * h15 + 4.3961595318e-04 * h16 + 2.1489115781e-02 * h17 + -1.5903865108e-02 * h18 + -3.5610871868e-03 * h19 + 2.3878152453e-03 * h20 + 6.7113720372e-04 * h21 + -8.1011419417e-03 * h22 + -1.9286975286e-02 * h23 + 2.0369356580e-02 * h24 + 4.5836570780e-02 * h25 + -9.6572554146e-04 * h26 + 8.1859531848e-03 * h27 + -4.4746712833e-03 * h28 + -1.3559468007e-03 * h29 + -5.3217347862e-03 * h30 + 1.0169516392e-03 * h31);
    k5 = tanh(-1.2346634330e-01 + 1.9426139229e-01 * h0 + 1.8530587643e-01 * h1 + 3.5939164595e-02 * h2 + 2.4295429696e-01 * h3 + -4.6538977202e-02 * h4 + -1.2778336289e-01 * h5 + 3.9569912923e-02 * h6 + -3.4456013086e-02 * h7 + -8.2019237926e-02 * h8 + -1.3022360825e-02 * h9 + 2.3449533852e-02 * h10 + 1.8099512821e-02 * h11 + 1.2734304176e-01 * h12 + 2.7783098962e-02 * h13 + -6.6259919999e-02 * h14 + 1.4602884790e-01 * h15 + 1.6766962949e-02 * h16 + 4.9439049878e-02 * h17 + -1.0379520731e-01 * h18 + -7.2833036887e-02 * h19 + 4.0637871238e-02 * h20 + -1.2052709435e-01 * h21 + -1.4226346658e-01 * h22 + 9.8445917472e-02 * h23 + -1.0316449375e-01 * h24 + 8.9897120544e-02 * h25 + -2.1760295441e-02 * h26 + -1.0202107162e-01 * h27 + 2.2888559608e-01 * h28 + 8.6457520763e-02 * h29 + -1.1390088472e-01 * h30 + -1.0509050468e-01 * h31);
    k6 = tanh(7.9480650071e-02 + 3.6074537281e-02 * h0 + -2.2929816317e-04 * h1 + 2.7204782569e-03 * h2 + 4.8427624971e-02 * h3 + -1.2555330433e-03 * h4 + -5.7990798569e-02 * h5 + 6.0191509842e-03 * h6 + 2.7756331953e-02 * h7 + -9.0344293841e-03 * h8 + 2.0881070485e-02 * h9 + 8.5824011933e-03 * h10 + -1.3593196467e-02 * h11 + -5.6484715610e-03 * h12 + 6.6818878866e-02 * h13 + -9.3701747671e-03 * h14 + 2.1408114612e-02 * h15 + 7.4769967737e-03 * h16 + 3.6877968887e-02 * h17 + -4.8086266663e-02 * h18 + -2.1717280886e-03 * h19 + 6.6527149107e-03 * h20 + -2.5186704517e-02 * h21 + -5.0291012671e-02 * h22 + -9.4389914355e-02 * h23 + -9.5186860638e-02 * h24 + -6.6716823032e-02 * h25 + 5.2787963935e-03 * h26 + 4.8477813621e-02 * h27 + -3.6961905837e-02 * h28 + 1.9448618033e-02 * h29 + -4.8325872579e-02 * h30 + -6.8345084631e-03 * h31);
    k7 = tanh(6.3568513681e-02 + -8.7704514094e-02 * h0 + -1.8208546286e-01 * h1 + 1.8323810816e-01 * h2 + -3.3646363902e-02 * h3 + -1.1848984294e-01 * h4 + 2.9395614078e-01 * h5 + -1.4823357800e-01 * h6 + 1.9821647902e-01 * h7 + 4.9437118812e-02 * h8 + -9.4254384729e-02 * h9 + -1.4797694199e-01 * h10 + -9.7851139481e-02 * h11 + -2.5313148636e-01 * h12 + -1.0940071938e-01 * h13 + -6.3583962821e-02 * h14 + -1.7361082321e-01 * h15 + 1.9422393373e-01 * h16 + 2.5462860025e-02 * h17 + 1.2749462023e-01 * h18 + 6.1977739967e-02 * h19 + -1.3483913937e-01 * h20 + 4.8370351301e-03 * h21 + 1.1680280822e-01 * h22 + 1.4210447709e-01 * h23 + 1.0942738487e-01 * h24 + -5.3114758704e-02 * h25 + 2.6094876509e-02 * h26 + -9.2535291020e-02 * h27 + -2.7187076196e-01 * h28 + 1.0915199750e-01 * h29 + -3.5358466544e-02 * h30 + 5.3133590296e-01 * h31);
    k8 = tanh(1.3902166548e-01 + -2.1085188651e-01 * h0 + -8.5361651906e-02 * h1 + -1.1121120786e-01 * h2 + -1.0477577242e-01 * h3 + 3.4201731800e-02 * h4 + 2.2077070590e-01 * h5 + 4.2100076181e-03 * h6 + 3.0975716864e-02 * h7 + 6.6509461195e-02 * h8 + -5.9947296511e-02 * h9 + -1.1121676045e-01 * h10 + 6.0938952558e-02 * h11 + 1.2493263260e-02 * h12 + -1.3745984749e-01 * h13 + 8.6360430761e-02 * h14 + -1.1182145493e-02 * h15 + -8.4101048221e-02 * h16 + -1.4683499847e-01 * h17 + 1.8107354394e-01 * h18 + 1.2693086361e-01 * h19 + -7.2666779514e-02 * h20 + 8.4214293273e-02 * h21 + 1.4379074033e-01 * h22 + 1.0621830060e-01 * h23 + 1.5145308392e-01 * h24 + -1.1434188174e-01 * h25 + -5.5350188176e-03 * h26 + 1.0024095499e-01 * h27 + -2.4620241615e-01 * h28 + -4.7527555476e-02 * h29 + 1.0025205256e-02 * h30 + 8.2967093783e-02 * h31);
    k9 = tanh(-1.9851988360e-01 + -9.5980539134e-02 * h0 + -2.5787352120e-02 * h1 + 5.1302475750e-02 * h2 + -1.2563939603e-01 * h3 + 9.7731630768e-02 * h4 + 2.2143678043e-01 * h5 + 7.9413453650e-02 * h6 + -4.1664316168e-02 * h7 + 1.4816354548e-02 * h8 + -1.7888217623e-01 * h9 + -1.5988357553e-02 * h10 + -3.1163536401e-02 * h11 + -1.0238854190e-01 * h12 + -1.8858975673e-01 * h13 + 7.3417291531e-02 * h14 + -6.1053896627e-02 * h15 + 2.6444086003e-02 * h16 + -1.4609450363e-01 * h17 + 2.3531319979e-01 * h18 + -3.5463201776e-03 * h19 + -1.2092389341e-01 * h20 + -7.5320779463e-02 * h21 + 1.0782974383e-01 * h22 + 1.7505230895e-02 * h23 + -1.6864707960e-02 * h24 + -1.5059054900e-01 * h25 + -2.6950690094e-01 * h26 + 7.2987822565e-02 * h27 + -2.6147945078e-01 * h28 + -8.8685421305e-02 * h29 + -7.6833084016e-03 * h30 + -4.7514448299e-02 * h31);
    k10 = tanh(1.2645774131e-01 + -1.6490348481e-01 * h0 + 5.3422237850e-02 * h1 + -9.7528646340e-02 * h2 + -2.4160291527e-01 * h3 + 1.0279844414e-01 * h4 + 2.6555843407e-01 * h5 + -1.5585928126e-01 * h6 + -1.7634982937e-01 * h7 + 1.7257480617e-01 * h8 + -1.2842524249e-01 * h9 + -9.3224370688e-02 * h10 + 8.5636044814e-02 * h11 + -2.8355670083e-02 * h12 + -1.1806736477e-01 * h13 + 7.9272010692e-02 * h14 + 2.0457625368e-02 * h15 + -1.4407617713e-01 * h16 + -1.8521510686e-01 * h17 + 6.4773313745e-02 * h18 + 9.1334336181e-02 * h19 + -9.9534039634e-02 * h20 + 1.0078136150e-01 * h21 + 2.0849065106e-01 * h22 + 3.1023182275e-02 * h23 + 1.2775966134e-01 * h24 + 2.4308039389e-02 * h25 + -1.8897605364e-02 * h26 + 1.0657686744e-01 * h27 + -2.4124515004e-01 * h28 + -1.2116268349e-01 * h29 + 6.6048107636e-02 * h30 + 1.1829037553e-01 * h31);
    k11 = tanh(1.4799593535e-01 + -7.2063669410e-02 * h0 + -3.3704623362e-02 * h1 + 6.5205763414e-02 * h2 + -1.0480208458e-03 * h3 + -8.7646592972e-03 * h4 + 1.1703232179e-01 * h5 + -6.9395507979e-02 * h6 + 2.8485203082e-02 * h7 + 1.8629355820e-02 * h8 + -6.1904698431e-02 * h9 + -2.6352156689e-02 * h10 + -1.1260548554e-02 * h11 + -5.3436608616e-02 * h12 + 1.6612260795e-02 * h13 + -3.8104885692e-02 * h14 + -1.0007391564e-01 * h15 + -4.9879621285e-03 * h16 + 6.0567647589e-02 * h17 + 9.9452217229e-02 * h18 + 2.7704130040e-03 * h19 + -2.7834317424e-02 * h20 + 6.4795897084e-02 * h21 + 5.0530649424e-02 * h22 + 9.1261358991e-02 * h23 + -9.0013831292e-02 * h24 + -8.1729315070e-02 * h25 + -2.8329722602e-02 * h26 + 1.5344065683e-01 * h27 + -1.1567351073e-01 * h28 + -7.3211304070e-02 * h29 + 6.7265880267e-02 * h30 + 5.7942333669e-02 * h31);
    k12 = tanh(-1.7568382055e-01 + -9.0630898181e-02 * h0 + -1.6547075433e-02 * h1 + 1.4548505446e-04 * h2 + -1.2669098055e-01 * h3 + 3.1738570527e-02 * h4 + 1.2626486572e-01 * h5 + 7.6377174549e-03 * h6 + 4.1197985481e-02 * h7 + 2.4513828070e-02 * h8 + -7.9763344292e-02 * h9 + 1.2473550519e-02 * h10 + 2.4513436146e-02 * h11 + -5.0578811385e-02 * h12 + 2.1371865683e-02 * h13 + -4.1018188943e-03 * h14 + -1.2246059577e-01 * h15 + 1.8732055799e-02 * h16 + -1.4390305682e-01 * h17 + 1.3531116434e-01 * h18 + 4.9982206398e-03 * h19 + -4.8073133626e-02 * h20 + 4.9075915374e-03 * h21 + 7.0194683443e-02 * h22 + 4.8224186851e-02 * h23 + 5.6344763437e-02 * h24 + -3.4540481244e-02 * h25 + -6.2203712123e-02 * h26 + 1.6994563223e-02 * h27 + -1.7717602551e-01 * h28 + -8.0949180632e-02 * h29 + -5.1748159809e-02 * h30 + 3.8669285505e-02 * h31);
    k13 = tanh(5.2071309898e-02 + 5.9638260183e-02 * h0 + 5.1709900207e-02 * h1 + 2.1670802426e-02 * h2 + 3.5555797614e-02 * h3 + -1.4215336794e-02 * h4 + -2.8677658899e-02 * h5 + 2.6397367135e-02 * h6 + 3.2893974447e-02 * h7 + -2.5677438680e-02 * h8 + -6.0653282924e-03 * h9 + 5.3858319416e-02 * h10 + -4.1048406749e-02 * h11 + 5.9632201361e-02 * h12 + -2.1220923898e-03 * h13 + -4.4757047507e-02 * h14 + -2.6190667358e-02 * h15 + 1.7723207801e-03 * h16 + 1.7706436549e-01 * h17 + -8.2378644125e-02 * h18 + -6.3445799526e-02 * h19 + -1.7553246105e-02 * h20 + -3.7430597402e-02 * h21 + -2.8764136148e-02 * h22 + -8.4550417645e-02 * h23 + -2.8180289099e-02 * h24 + 1.3520523494e-01 * h25 + -6.4268763844e-03 * h26 + 2.8411599935e-02 * h27 + 1.1605949106e-01 * h28 + 8.0995716999e-02 * h29 + -1.1023184324e-01 * h30 + -1.0376328935e-02 * h31);
    k14 = tanh(1.8275764168e-01 + 5.9686278690e-02 * h0 + 3.7425077784e-02 * h1 + 2.7979436666e-02 * h2 + 1.8488264670e-01 * h3 + -5.8627130480e-02 * h4 + -2.0055452154e-01 * h5 + 7.7504240041e-02 * h6 + -1.6192174573e-02 * h7 + 6.3987608713e-03 * h8 + 4.8937640007e-02 * h9 + 3.0262974415e-02 * h10 + -6.2647734670e-02 * h11 + 9.2384401346e-02 * h12 + 1.6372395289e-01 * h13 + -5.5342028547e-03 * h14 + -9.4655748632e-02 * h15 + 6.2466332200e-02 * h16 + 1.0076191139e-01 * h17 + -6.2333456241e-02 * h18 + -4.7439463127e-02 * h19 + 3.4834501032e-02 * h20 + 8.4685471481e-02 * h21 + -1.0472197071e-01 * h22 + -1.3002712229e-01 * h23 + 6.8873662231e-02 * h24 + -7.9127145749e-02 * h25 + 1.0356996588e-01 * h26 + -4.1412725749e-02 * h27 + 1.2422585591e-01 * h28 + 1.8571242593e-01 * h29 + -1.3415170686e-01 * h30 + -3.6488592563e-02 * h31);
    k15 = tanh(-3.1670301679e-02 + -1.0594003701e-03 * h0 + 1.8076504008e-04 * h1 + -5.4775503311e-03 * h2 + -4.6062523627e-04 * h3 + 5.3826776012e-04 * h4 + -1.6165809635e-03 * h5 + -1.6373268235e-03 * h6 + -1.5426200643e-03 * h7 + -5.0937708534e-05 * h8 + -7.6530699528e-04 * h9 + -5.3522330078e-04 * h10 + 2.5121746147e-03 * h11 + 2.2508078820e-03 * h12 + -2.9822495804e-03 * h13 + 2.5245767723e-03 * h14 + 2.5112148482e-03 * h15 + -9.5351490023e-05 * h16 + -7.6027568735e-03 * h17 + 1.6629196963e-03 * h18 + 5.8844661301e-04 * h19 + -7.8403526883e-04 * h20 + -1.4751059105e-03 * h21 + 1.2644490170e-03 * h22 + 2.9921227224e-03 * h23 + -5.0820382739e-03 * h24 + -5.8428630252e-03 * h25 + 4.1193672890e-04 * h26 + -6.1610196645e-03 * h27 + 3.1975684020e-03 * h28 + 5.2085180313e-04 * h29 + 3.1661956125e-03 * h30 + -1.0006163825e-04 * h31);
    k16 = tanh(5.7144958411e-02 + -1.0224746558e-01 * h0 + -4.1000252248e-02 * h1 + 3.3685964977e-02 * h2 + -5.6108218350e-02 * h3 + -1.4004633185e-04 * h4 + 4.0680886732e-02 * h5 + -9.7945450394e-03 * h6 + -2.2232377673e-02 * h7 + 3.4725088419e-02 * h8 + -3.4465827634e-02 * h9 + -2.5924170946e-02 * h10 + 6.0439261688e-03 * h11 + -3.2355685627e-02 * h12 + -8.9938736935e-02 * h13 + -3.4630411125e-02 * h14 + -1.8582954759e-03 * h15 + 1.9784012156e-02 * h16 + 2.3939516452e-02 * h17 + 7.8223254979e-02 * h18 + 2.6902174427e-02 * h19 + -1.7649909260e-02 * h20 + 4.4840522131e-02 * h21 + 9.0887681670e-02 * h22 + -2.2490868718e-02 * h23 + 1.9870779966e-02 * h24 + 1.3054382194e-02 * h25 + -2.3474648735e-02 * h26 + 1.3955922486e-01 * h27 + -1.8717674311e-02 * h28 + -6.1342870187e-02 * h29 + 2.1388219227e-02 * h30 + 3.3663119975e-02 * h31);
    k17 = tanh(1.3416641276e-01 + -3.2169231267e-01 * h0 + 7.3489919547e-02 * h1 + 5.2423113221e-02 * h2 + -8.2401591139e-01 * h3 + 3.7862832638e-01 * h4 + 3.9662059629e-01 * h5 + 7.4976926877e-02 * h6 + -2.9983426583e-01 * h7 + 2.2888357942e-01 * h8 + 2.3936784821e-02 * h9 + -4.1467181821e-02 * h10 + 2.1257076870e-01 * h11 + 1.8414677324e-02 * h12 + 4.8658173422e-02 * h13 + 1.5432196275e-01 * h14 + 1.0456625602e-01 * h15 + -3.4752507729e-01 * h16 + -1.4886599022e-01 * h17 + -7.2632853425e-02 * h18 + -2.7517377171e-01 * h19 + 3.6537633854e-02 * h20 + -7.3558544409e-02 * h21 + 3.3983679638e-01 * h22 + 1.0879729137e-01 * h23 + 1.3915991357e-01 * h24 + 5.9050400103e-03 * h25 + 7.8012630046e-02 * h26 + -8.7683278117e-02 * h27 + -3.1675680342e-01 * h28 + 1.1117108019e-01 * h29 + 5.5545977048e-02 * h30 + -8.4141493999e-02 * h31);
    k18 = tanh(5.3226813600e-02 + 1.6396225874e-01 * h0 + 2.3312037161e-02 * h1 + 1.0706607222e-01 * h2 + 7.2698689554e-02 * h3 + 2.3835028765e-02 * h4 + -1.3513557812e-01 * h5 + 1.4106476603e-01 * h6 + -6.1227965601e-02 * h7 + -2.7592242159e-02 * h8 + 8.9853264547e-02 * h9 + 2.9258597761e-02 * h10 + -5.7398798854e-02 * h11 + 7.8417445645e-02 * h12 + -2.8516822613e-02 * h13 + 3.5728629335e-02 * h14 + 7.7753913124e-02 * h15 + -1.0152166773e-01 * h16 + 1.9628928435e-01 * h17 + -1.2578666149e-01 * h18 + -4.5089480317e-02 * h19 + 9.9672972803e-02 * h20 + -4.7721001518e-02 * h21 + -8.9496557860e-02 * h22 + -5.6458337933e-02 * h23 + -4.3136741833e-02 * h24 + 1.7382897938e-02 * h25 + 4.9544011710e-02 * h26 + -1.0810371729e-01 * h27 + 2.2414911964e-01 * h28 + 1.3302461626e-01 * h29 + 4.3335848446e-02 * h30 + -9.9598792609e-02 * h31);
    k19 = tanh(1.8893450315e-01 + 6.7651451216e-02 * h0 + 2.7303715333e-02 * h1 + -1.2206089304e-01 * h2 + 1.1459878087e-01 * h3 + -4.4911243317e-03 * h4 + -1.6279143505e-01 * h5 + 4.4260874914e-03 * h6 + 2.6553759445e-02 * h7 + -2.2139250709e-02 * h8 + 6.3988868898e-02 * h9 + 4.5190496793e-02 * h10 + -1.4190032532e-02 * h11 + 1.0558868741e-01 * h12 + 3.7031529171e-02 * h13 + 2.4666000137e-02 * h14 + 9.7950998660e-02 * h15 + -1.9464599331e-02 * h16 + 8.5566127718e-02 * h17 + -9.0071520982e-02 * h18 + -3.3291284637e-02 * h19 + -2.4008494145e-02 * h20 + -6.1838447064e-02 * h21 + -7.5177294284e-02 * h22 + -9.8368865810e-02 * h23 + -2.6819439094e-02 * h24 + -1.5796995390e-02 * h25 + 1.8876588238e-02 * h26 + -1.7478753748e-01 * h27 + 2.1212773364e-01 * h28 + 6.3027864787e-02 * h29 + 1.4711662235e-03 * h30 + -2.8559990348e-02 * h31);
    k20 = tanh(1.7804055592e-01 + 1.1824653054e-01 * h0 + 5.9225964196e-03 * h1 + -2.6017355823e-02 * h2 + 4.9687105153e-02 * h3 + -2.1342450196e-02 * h4 + -1.0190352825e-01 * h5 + 9.4476592017e-03 * h6 + 1.5300706092e-03 * h7 + -2.2678867593e-02 * h8 + 7.2881096970e-02 * h9 + 1.1145148945e-02 * h10 + -1.7732108815e-02 * h11 + 5.2936064248e-02 * h12 + 1.5727080479e-01 * h13 + -2.9415544512e-02 * h14 + 1.5477493634e-02 * h15 + -4.4760560400e-02 * h16 + -6.8592577096e-02 * h17 + -1.1207233735e-01 * h18 + 8.9040377479e-03 * h19 + 3.1927253370e-02 * h20 + 2.9120730046e-02 * h21 + -6.6385490269e-02 * h22 + -1.0448242377e-01 * h23 + -1.3278109442e-02 * h24 + 1.5438779206e-01 * h25 + 6.9403360575e-02 * h26 + 5.9787452474e-02 * h27 + 1.3028182382e-01 * h28 + 8.0701874728e-02 * h29 + -5.4857315393e-02 * h30 + -1.5475200667e-02 * h31);
    k21 = tanh(1.2338792189e-01 + -9.6378678015e-02 * h0 + -2.2145973643e-02 * h1 + 7.5755127864e-02 * h2 + -4.4214032291e-03 * h3 + -2.5341418721e-02 * h4 + 1.4002303444e-01 * h5 + 1.6402174980e-02 * h6 + 5.9305419995e-02 * h7 + 4.0627964775e-02 * h8 + -7.3162081301e-02 * h9 + -5.3463469191e-02 * h10 + -2.7833633667e-02 * h11 + -7.6266561640e-02 * h12 + -8.4677596272e-02 * h13 + -9.4373326204e-03 * h14 + 1.0944615501e-02 * h15 + 2.9759946681e-02 * h16 + -7.3675706155e-04 * h17 + 1.3825613635e-01 * h18 + -1.1615508722e-03 * h19 + -1.3359852495e-02 * h20 + -3.0138969952e-02 * h21 + 4.3174444514e-02 * h22 + 7.7512432201e-03 * h23 + 8.8619291385e-02 * h24 + -1.5472364872e-01 * h25 + -2.3884297167e-02 * h26 + 1.4527103667e-01 * h27 + -7.2258658744e-02 * h28 + -1.2728781197e-01 * h29 + 3.8297493251e-02 * h30 + 4.5035616821e-02 * h31);
    k22 = tanh(-3.3345701702e-02 + 1.1078514888e-02 * h0 + 2.5390462879e-02 * h1 + 2.1229979453e-01 * h2 + -1.5846752033e-01 * h3 + -3.1214465952e-02 * h4 + 2.1226641496e-01 * h5 + 3.0846390184e-02 * h6 + 1.1324732280e-01 * h7 + 1.9084392871e-02 * h8 + -3.2801827865e-01 * h9 + 1.9301544767e-02 * h10 + -1.7672909814e-01 * h11 + -1.1738179766e-01 * h12 + -1.9542279382e-01 * h13 + -1.5378000614e-01 * h14 + -2.8459918996e-02 * h15 + 1.1461814668e-01 * h16 + -8.4434282808e-02 * h17 + 9.0476838514e-02 * h18 + -1.7790692708e-01 * h19 + -5.3961809828e-02 * h20 + -1.4982109280e-02 * h21 + 2.1377180752e-01 * h22 + -4.1245483877e-02 * h23 + -1.1276416666e-01 * h24 + -1.9372359102e-01 * h25 + -6.7346883321e-02 * h26 + 1.3319291902e-01 * h27 + -3.9379895269e-02 * h28 + -1.6095556519e-01 * h29 + 7.3468114382e-02 * h30 + 1.4219947119e-01 * h31);
    k23 = tanh(1.6145926378e-01 + -1.4249656532e-02 * h0 + 1.6865733654e-02 * h1 + 1.1921826866e-01 * h2 + 9.0301373086e-03 * h3 + -6.0022691344e-02 * h4 + -1.6330419093e-01 * h5 + 8.3924824446e-02 * h6 + -3.3168800895e-02 * h7 + 9.0008942677e-03 * h8 + 1.0551303784e-01 * h9 + 5.5796966018e-02 * h10 + -1.3589624914e-02 * h11 + 1.3916571595e-01 * h12 + 1.4096619926e-01 * h13 + -3.9513416725e-02 * h14 + 1.9667873142e-02 * h15 + 2.6077133736e-02 * h16 + 1.8410773822e-01 * h17 + -1.7435973581e-01 * h18 + 2.1864368375e-02 * h19 + -3.9538684007e-02 * h20 + -1.1472947289e-01 * h21 + -5.3220050626e-02 * h22 + -7.7202861660e-02 * h23 + -6.6345991878e-04 * h24 + -5.0127784372e-02 * h25 + 4.6084382572e-02 * h26 + -5.5857196381e-02 * h27 + 1.3752898572e-01 * h28 + 1.2116501516e-01 * h29 + -7.1283698668e-03 * h30 + 3.3120855505e-02 * h31);
    k24 = tanh(-1.5813781614e-01 + -4.9283748474e-02 * h0 + -1.7174860718e-02 * h1 + 6.3011487874e-02 * h2 + -3.8663369109e-02 * h3 + 1.0967560467e-02 * h4 + 6.5420087459e-02 * h5 + -1.3776121344e-02 * h6 + -2.6661883438e-02 * h7 + 9.6201335581e-03 * h8 + -6.0221783207e-02 * h9 + -3.2002891572e-02 * h10 + 5.6007809313e-03 * h11 + -1.5840298266e-02 * h12 + -1.5761404566e-02 * h13 + -2.2962966131e-02 * h14 + -5.4734089044e-02 * h15 + 1.1358118716e-02 * h16 + -9.1833468552e-02 * h17 + 8.6176627462e-02 * h18 + 4.7132418755e-03 * h19 + 1.3084678987e-02 * h20 + -3.3893350461e-02 * h21 + 4.9506057283e-02 * h22 + 7.5256670001e-02 * h23 + 9.5042563981e-02 * h24 + -5.9894469504e-02 * h25 + -2.5050990230e-02 * h26 + 6.1819821379e-02 * h27 + -6.3606085487e-02 * h28 + -2.4914175342e-02 * h29 + -1.8656083631e-02 * h30 + 2.4760975524e-03 * h31);
    k25 = tanh(-1.1131477018e-01 + 2.2590622991e-01 * h0 + 1.4797962795e-02 * h1 + -9.5738183857e-02 * h2 + 3.1581981757e-01 * h3 + -1.1050710914e-01 * h4 + -6.8839842389e-02 * h5 + 1.9649571260e-01 * h6 + 5.9357643653e-02 * h7 + -1.1346175847e-01 * h8 + -3.7538533557e-02 * h9 + 1.5098599504e-01 * h10 + -1.2544882941e-01 * h11 + -8.4340872712e-02 * h12 + 2.9789531617e-02 * h13 + -1.6839480079e-01 * h14 + 8.0680750053e-02 * h15 + -4.6872374617e-02 * h16 + 2.4457706618e-01 * h17 + -1.3823999006e-01 * h18 + -3.2905188692e-01 * h19 + 6.8351211809e-02 * h20 + 1.8749138105e-02 * h21 + -1.5665411220e-01 * h22 + 1.2121376013e-02 * h23 + -1.6983189320e-01 * h24 + 1.4745153225e-01 * h25 + -1.2117440905e-01 * h26 + -9.6501563678e-02 * h27 + 3.0304860540e-01 * h28 + 2.3597837386e-01 * h29 + -2.1394910439e-01 * h30 + -8.4190409941e-02 * h31);
    k26 = tanh(-1.1024492218e-01 + 9.4263953892e-02 * h0 + 3.9986383137e-02 * h1 + 3.8576981746e-01 * h2 + -2.8088098407e-02 * h3 + 1.4764392575e-01 * h4 + 4.3695941191e-01 * h5 + 5.0803985595e-02 * h6 + 2.8604069092e-01 * h7 + 1.1677484906e-01 * h8 + -4.2145567255e-01 * h9 + 1.5113977932e-02 * h10 + -3.5899269610e-01 * h11 + -2.8303837652e-01 * h12 + -4.6566005297e-03 * h13 + -3.2877641225e-01 * h14 + -1.5576808959e-01 * h15 + -5.0655410291e-03 * h16 + -8.0561667645e-02 * h17 + 2.9166449205e-01 * h18 + -2.1353324202e-01 * h19 + -1.3642583840e-01 * h20 + 7.4976974841e-02 * h21 + 1.4568079166e-01 * h22 + -3.3482398687e-02 * h23 + 1.1056751301e-01 * h24 + -1.5638286278e-01 * h25 + -2.3540026773e-01 * h26 + 1.0514590701e-01 * h27 + -1.5973661248e-01 * h28 + -6.7199888962e-02 * h29 + 2.6764758905e-02 * h30 + 2.4054867593e-01 * h31);
    k27 = tanh(-2.9760512969e-02 + 1.0406759748e-01 * h0 + 4.7956979275e-03 * h1 + -7.4305528545e-02 * h2 + 2.1095956394e-01 * h3 + -2.6830285252e-02 * h4 + -1.5055237535e-01 * h5 + -3.3283139836e-03 * h6 + -2.1069526688e-02 * h7 + -2.7697368120e-02 * h8 + 7.5520273753e-03 * h9 + 7.0013071925e-02 * h10 + -3.4464656808e-02 * h11 + 6.4638679958e-02 * h12 + 3.4386572373e-02 * h13 + 8.5686785476e-02 * h14 + 1.2611960697e-01 * h15 + -9.3230786325e-02 * h16 + 1.2006905009e-01 * h17 + -1.6797183596e-01 * h18 + -7.6418043107e-02 * h19 + 1.7322624267e-02 * h20 + -2.6164741501e-02 * h21 + -1.2268188511e-01 * h22 + -1.3109466658e-01 * h23 + -9.1357890450e-02 * h24 + 7.1878939284e-02 * h25 + 2.2687072646e-02 * h26 + -2.1189202660e-01 * h27 + 1.8996499900e-01 * h28 + 5.7765889265e-02 * h29 + -1.3945483219e-01 * h30 + -7.9028512897e-02 * h31);
    k28 = tanh(9.9013236050e-02 + -4.5143780201e-04 * h0 + -2.1272049328e-03 * h1 + 1.7883782711e-03 * h2 + 3.9058208852e-03 * h3 + -4.7975941705e-04 * h4 + 1.1892176295e-02 * h5 + 3.4237304583e-03 * h6 + 6.2904867403e-03 * h7 + 7.9259161361e-04 * h8 + 7.3602034671e-04 * h9 + -4.4902901753e-04 * h10 + -1.0025042582e-02 * h11 + -1.8852850636e-02 * h12 + 2.2686482203e-02 * h13 + -9.9996530881e-03 * h14 + -4.2704824569e-02 * h15 + 2.0023036058e-04 * h16 + 2.5900651740e-03 * h17 + 5.9531689111e-03 * h18 + -2.1599162010e-03 * h19 + 4.3636382025e-03 * h20 + 2.0174835719e-02 * h21 + -2.8411753814e-03 * h22 + -2.9916870265e-02 * h23 + 6.7107277229e-02 * h24 + -4.0143193119e-02 * h25 + -2.2097569479e-03 * h26 + 8.6581198447e-03 * h27 + -3.0424804822e-02 * h28 + -3.3414014212e-03 * h29 + 8.6986917557e-03 * h30 + -6.3764217484e-04 * h31);
    k29 = tanh(8.8771476965e-02 + -2.8796515083e-01 * h0 + -6.8803390256e-02 * h1 + 1.2532835670e-01 * h2 + -3.0042066105e-01 * h3 + 1.2715446344e-01 * h4 + 1.2106130831e-01 * h5 + -8.9942506541e-02 * h6 + -3.1928755208e-02 * h7 + 8.0949920964e-02 * h8 + 8.5129487868e-03 * h9 + -1.5837646668e-01 * h10 + 2.0448443877e-01 * h11 + 2.8639656229e-02 * h12 + -1.5222941099e-01 * h13 + 9.5116782213e-02 * h14 + 2.5129580746e-02 * h15 + -1.3595235115e-01 * h16 + -1.7243306226e-01 * h17 + 5.2334000328e-02 * h18 + 1.9147991907e-01 * h19 + -5.4299254082e-02 * h20 + -8.0242121280e-02 * h21 + 1.8954163175e-01 * h22 + 5.6262172412e-02 * h23 + 5.7577737118e-02 * h24 + -3.6226676626e-02 * h25 + 3.6009812891e-02 * h26 + -5.3118129694e-02 * h27 + -2.0078453865e-01 * h28 + -9.6827625317e-02 * h29 + 1.7192771283e-01 * h30 + -1.0346802647e-02 * h31);
    k30 = tanh(1.0917752347e-01 + 4.8763655506e-02 * h0 + 8.6005049884e-03 * h1 + -1.7713561720e-02 * h2 + 3.6056668186e-02 * h3 + 3.1100346390e-03 * h4 + -4.3553868366e-02 * h5 + 2.1846448567e-02 * h6 + 3.0838329851e-02 * h7 + -1.1900179139e-02 * h8 + 5.8821707488e-02 * h9 + 2.3059679091e-02 * h10 + -1.5139528713e-02 * h11 + 2.7674744313e-02 * h12 + 3.0676712188e-02 * h13 + 1.3355014217e-02 * h14 + -2.1259520119e-02 * h15 + -1.0084581385e-02 * h16 + 1.3370418871e-01 * h17 + -5.1397357093e-02 * h18 + -7.6867346369e-03 * h19 + -8.3228795052e-03 * h20 + -1.7382594754e-02 * h21 + -5.5764820493e-02 * h22 + 4.5050002950e-02 * h23 + -4.0797774334e-03 * h24 + -1.3837033853e-02 * h25 + 1.9545704994e-02 * h26 + -9.1955059180e-02 * h27 + 1.5123262361e-02 * h28 + 2.7472494414e-02 * h29 + -8.4104116776e-02 * h30 + -1.2937217942e-02 * h31);
    k31 = tanh(1.0861061193e-01 + 8.6986329467e-02 * h0 + 2.1719651232e-02 * h1 + -6.0273356063e-02 * h2 + 7.8117120995e-02 * h3 + 1.2893005372e-02 * h4 + -9.6035667748e-02 * h5 + 1.5251730540e-02 * h6 + 2.3345768911e-02 * h7 + -1.2937525552e-02 * h8 + 5.1623131631e-02 * h9 + 2.0511938715e-02 * h10 + -6.1483017698e-03 * h11 + 4.1074655400e-02 * h12 + 1.3072547842e-02 * h13 + 3.8845725274e-02 * h14 + 8.3044456207e-02 * h15 + -3.0902520273e-02 * h16 + 3.6349804498e-02 * h17 + -5.7082575270e-02 * h18 + -5.8777323932e-03 * h19 + 4.4110335093e-03 * h20 + 1.0413657221e-02 * h21 + -5.4616241080e-02 * h22 + -1.0120238242e-01 * h23 + -9.4410800130e-02 * h24 + 1.0028996728e-01 * h25 + 2.8116797611e-02 * h26 + -1.3766669761e-01 * h27 + 7.7731108025e-02 * h28 + 1.6970499447e-02 * h29 + -8.5468660054e-02 * h30 + -1.5978624037e-02 * h31);
    acc = -3.1382062587e-02 + -1.0220893751e-01 * k0 + -7.7281641791e-02 * k1 + 1.1317955888e-01 * k2 + -2.9044214138e-01 * k3 + -1.8364963328e-03 * k4 + -3.2000141008e-01 * k5 + -1.0722378555e-02 * k6 + 2.8781714013e-01 * k7 + 1.6087443080e-01 * k8 + 3.0539099916e-01 * k9 + 2.8236369402e-01 * k10 + 3.5767663675e-02 * k11 + 8.6140815707e-02 * k12 + -4.9967104790e-02 * k13 + -1.4265424639e-01 * k14 + 3.5535756064e-05 * k15 + 4.7439240121e-02 * k16 + 5.2245824132e-01 * k17 + -4.2349932300e-01 * k18 + -7.7914625884e-02 * k19 + -7.6025900082e-02 * k20 + 9.0233298016e-02 * k21 + 4.9621930144e-01 * k22 + -1.1903468178e-01 * k23 + 5.5075866614e-02 * k24 + -3.9845618981e-01 * k25 + 4.6059366320e-01 * k26 + -2.7927671774e-01 * k27 + 2.2343829882e-04 * k28 + 1.4981190658e-01 * k29 + -4.9718742512e-02 * k30 + -7.5897181893e-02 * k31;
    gsum = gsum + 1 * tanh(acc);
    // ensemble member 1
    h0 = tanh(-1.2947539303e-01 + 2.8322444907e-01 * x0 + -2.0628653482e-01 * x1 + 6.2696553069e-02 * x2 + 9.3356401575e-02 * x3 + 3.1522214960e-01 * x4 + 1.3167415017e-01 * x5);
    h1 = tanh(-2.0268304239e-01 + -2.6401427779e-01 * x0 + 2.4837658399e-01 * x1 + -1.5171403769e-01 * x2 + -3.6292465929e-03 * x3 + -1.1140740166e-01 * x4 + 9.2285567743e-02 * x5);
    h2 = tanh(2.4212849231e-01 + 2.4072140596e-01 * x0 + -1.3976906183e-01 * x1 + 1.0731063441e-01 * x2 + -3.1592275758e-02 * x3 + -1.5941730452e-01 * x4 + -1.0734432529e-01 * x5);
    h3 = tanh(-1.9224479487e-01 + 2.4100917616e-01 * x0 + 1.6395525285e-01 * x1 + -4.3226847478e-02 * x2 + 2.7557430171e-02 * x3 + -9.2824810161e-02 * x4 + -3.2206431610e-01 * x5);
    h4 = tanh(2.4370717214e-01 + -7.5961883883e-02 * x0 + 3.6984785078e-02 * x1 + 1.1174398177e-01 * x2 + 2.2428524783e-01 * x3 + -4.1269673581e-01 * x4 + 3.8262154863e-01 * x5);
    h5 = tanh(2.6194675982e-01 + 5.1282169096e-02 * x0 + 1.9184103496e-01 * x1 + 1.1325699324e-01 * x2 + -1.9788212065e-01 * x3 + 5.5107915683e-02 * x4 + -4.9359612054e-02 * x5);
    h6 = tanh(8.6268846476e-01 + 2.5646293880e-01 * x0 + -3.0926228410e-01 * x1 + 3.9372094946e-01 * x2 + -2.6870016141e-01 * x3 + -3.7924262935e-02 * x4 + -4.1160208586e-01 * x5);
    h7 = tanh(-3.3652679485e-01 + 2.2868859694e-01 * x0 + -1.3381567546e-02 * x1 + 1.8719344195e-02 * x2 + 2.9587787507e-01 * x3 + 2.4677620355e-01 * x4 + 2.4789702451e-01 * x5);
    h8 = tanh(4.6413776864e-02 + -1.4550799875e-01 * x0 + -5.4386245914e-02 * x1 + -3.8492659808e-01 * x2 + -1.5031334958e-01 * x3 + 3.1661842976e-02 * x4 + 3.5326213950e-02 * x5);
    h9 = tanh(-3.2578601969e-01 + 4.1467387943e-01 * x0 + 2.9425538507e-01 * x1 + -6.6681049837e-02 * x2 + -1.0422175827e-01 * x3 + 9.6170447620e-02 * x4 + 1.9797508917e-02 * x5);
    h10 = tanh(1.7326919308e-01 + -8.5385469818e-02 * x0 + 3.0235874161e-01 * x1 + 4.3446099809e-01 * x2 + -3.3503924908e-01 * x3 + -1.3113437525e-02 * x4 + -6.2391193119e-02 * x5);
    h11 = tanh(-2.2376954191e-01 + 4.1539518831e-02 * x0 + 6.4460305615e-02 * x1 + -2.5071872834e-01 * x2 + -5.4572269398e-01 * x3 + 9.0925563456e-03 * x4 + -1.4020057778e-01 * x5);
    h12 = tanh(3.8047814052e-01 + 2.0617339939e-01 * x0 + -8.3160248750e-03 * x1 + 3.1593490720e-01 * x2 + 1.8042527751e-01 * x3 + 1.4584448022e-01 * x4 + 1.4566285255e-01 * x5);
    h13 = tanh(-8.3895426593e-02 + -3.1636612085e-01 * x0 + 1.8178505517e-01 * x1 + -2.6516305277e-01 * x2 + -3.5101201653e-01 * x3 + 3.2780314396e-02 * x4 + -3.9669885997e-02 * x5);
    h14 = tanh(9.6881315351e-03 + 2.9321761192e-01 * x0 + -1.9800417445e-01 * x1 + -2.8371736286e-01 * x2 + -9.6290727435e-02 * x3 + -1.0923804569e-03 * x4 + 8.8928193761e-02 * x5);
    h15 = tanh(5.3531572051e-02 + 3.2159224003e-01 * x0 + -3.0657021120e-01 * x1 + 1.0304093872e-02 * x2 + 2.2038859568e-01 * x3 + -2.7294720812e-01 * x4 + -3.1157476753e-01 * x5);
    h16 = tanh(4.6086971176e-02 + 7.2779948373e-02 * x0 + -3.2828340433e-02 * x1 + -1.6433136801e-01 * x2 + -7.2077701440e-02 * x3 + 4.2198546889e-01 * x4 + -7.6920086149e-02 * x5);
    h17 = tanh(1.6798976768e-01 + 1.3301296844e-01 * x0 + 1.7198498447e-01 * x1 + -3.0988897843e-01 * x2 + -2.3267149242e-01 * x3 + 3.3884357622e-01 * x4 + -2.8920523155e-01 * x5);
    h18 = tanh(5.4174915720e-02 + 3.0598965099e-01 * x0 + 5.6148903083e-02 * x1 + 2.9300468196e-01 * x2 + -2.7909207615e-01 * x3 + 5.0787125727e-01 * x4 + -3.7990585925e-01 * x5);
    h19 = tanh(8.7688552316e-02 + 1.0348633432e-01 * x0 + 2.1982103195e-01 * x1 + 3.1656276156e-01 * x2 + 4.2340009033e-01 * x3 + -2.7839761358e-01 * x4 + -3.4485119065e-01 * x5);
    h20 = tanh(-1.8339812316e-01 + -7.1062364463e-02 * x0 + 1.4608303839e-01 * x1 + 7.2556083950e-01 * x2 + -2.2246710912e-01 * x3 + 3.0333328747e-02 * x4 + -5.5136261009e-02 * x5);
    h21 = tanh(4.7686717766e-01 + -1.9908273938e-01 * x0 + -2.0260475998e-01 * x1 + 5.7845688111e-01 * x2 + 5.0381330581e-02 * x3 + 4.5250114493e-02 * x4 + 1.0577280333e+00 * x5);
    h22 = tanh(3.3946428532e-01 + 3.7631171459e-01 * x0 + 1.6867778433e-01 * x1 + 6.2532363930e-02 * x2 + 4.0014791790e-02 * x3 + 3.3728637856e-02 * x4 + 1.0094235169e-01 * x5);
    h23 = tanh(3.5103174494e-01 + -2.0143730173e-01 * x0 + -2.7995584880e-01 * x1 + -2.8779622693e-01 * x2 + 8.9463137128e-02 * x3 + 5.6752896328e-02 * x4 + 1.4270949998e-02 * x5);
    h24 = tanh(4.8228709224e-01 + 8.7180953912e-02 * x0 + 1.9571532806e-01 * x1 + 4.2465401414e-01 * x2 + -1.5817887440e-01 * x3 + -4.2789726927e-02 * x4 + 1.2720618887e+00 * x5);
    h25 = tanh(-5.0826379082e-01 + -2.2921883614e-01 * x0 + 3.7517236736e-01 * x1 + 8.3687829980e-02 * x2 + -4.8786519618e-03 * x3 + -2.9430741466e-01 * x4 + -3.5267348916e-01 * x5);
    h26 = tanh(2.6540204912e-01 + 4.0275544348e-01 * x0 + -1.5894078170e-01 * x1 + 5.3510714102e-01 * x2 + -1.6628350499e-02 * x3 + 6.0687467902e-01 * x4 + -2.5296797201e-01 * x5);
    h27 = tanh(2.3878346467e-01 + -8.7799151551e-02 * x0 + 6.8176957241e-02 * x1 + -1.4260956665e-01 * x2 + 4.1305025968e-02 * x3 + 5.4855205301e-02 * x4 + -9.4709368597e-02 * x5);
    h28 = tanh(-2.6054734489e-01 + -3.1111093083e-01 * x0 + -1.2374486073e-01 * x1 + -5.5872660848e-03 * x2 + 6.9683471494e-03 * x3 + -1.8700571061e-02 * x4 + 6.5407805830e-01 * x5);
    h29 = tanh(6.5209540192e-01 + 1.2367757322e+00 * x0 + -9.2032051017e-02 * x1 + 9.4822221605e-01 * x2 + -1.3594670550e-01 * x3 + 1.4054076107e-02 * x4 + 7.4305484384e-01 * x5);
    h30 = tanh(-4.5788970342e-01 + -5.3345588809e-01 * x0 + 1.8380334454e-02 * x1 + -4.8519365918e-01 * x2 + 2.3354492542e-01 * x3 + -6.2200283637e-02 * x4 + 4.9349945531e-01 * x5);
    h31 = tanh(-3.9785764553e-01 + -5.9254054481e-01 * x0 + -2.3705404195e-01 * x1 + -2.1048272375e-01 * x2 + 1.4100185713e-01 * x3 + -1.7077143929e-02 * x4 + -2.7823308123e-01 * x5);
    k0 = tanh(-1.1329791540e-01 + -1.9958175189e-02 * h0 + -1.3961622140e-02 * h1 + -4.7469207020e-03 * h2 + 4.3830240748e-02 * h3 + 4.9477939795e-02 * h4 + 1.2872133432e-01 * h5 + -1.1973160955e-02 * h6 + -1.3876285393e-02 * h7 + 4.0951135145e-02 * h8 + 5.9546339760e-02 * h9 + -1.1092226724e-02 * h10 + 7.5565530974e-02 * h11 + -1.1012415966e-01 * h12 + 5.1944605049e-02 * h13 + -3.5588709962e-03 * h14 + 1.8569227953e-02 * h15 + -1.0713828825e-02 * h16 + 1.7501402207e-02 * h17 + 7.9092764794e-02 * h18 + 4.4329557120e-02 * h19 + 2.0185657614e-02 * h20 + 1.1904853637e-01 * h21 + -8.6773222427e-02 * h22 + -3.2593974471e-02 * h23 + -1.9766324574e-01 * h24 + 1.7770559916e-01 * h25 + 6.8885657563e-02 * h26 + -1.8652992336e-02 * h27 + 7.7220045352e-02 * h28 + -1.4586513757e-03 * h29 + -4.2327094614e-02 * h30 + -1.1817972027e-01 * h31);
    k1 = tanh(-1.3125588111e-01 + 1.3243592762e-02 * h0 + 7.0037592513e-02 * h1 + -1.6995478008e-02 * h2 + 1.1516606344e-02 * h3 + 1.2195212691e-01 * h4 + 9.1165163655e-02 * h5 + -4.9412471388e-02 * h6 + 6.9980430470e-03 * h7 + 2.0318540871e-02 * h8 + -1.6442626325e-01 * h9 + 6.7118119402e-02 * h10 + -1.3259511675e-01 * h11 + 1.5333343867e-01 * h12 + -6.9140102606e-02 * h13 + -5.1033579296e-02 * h14 + -5.9217649751e-02 * h15 + 4.4398220729e-02 * h16 + 1.2601388332e-01 * h17 + -6.9709184162e-02 * h18 + -3.1184787925e-02 * h19 + -4.1836888272e-02 * h20 + -1.3586591389e-01 * h21 + -9.5257791328e-02 * h22 + -5.1315220133e-02 * h23 + 7.4644848532e-02 * h24 + -2.4325557976e-02 * h25 + 8.0197248614e-03 * h26 + 3.1902925781e-02 * h27 + -2.2258685846e-01 * h28 + -1.5217157403e-02 * h29 + -9.1729028939e-02 * h30 + 2.0225661452e-01 * h31);
    k2 = tanh(1.1013896210e-01 + -1.1125343906e-03 * h0 + 2.8393388654e-03 * h1 + -3.3293012724e-03 * h2 + 1.8255717348e-03 * h3 + 5.4980183074e-03 * h4 + 3.5996287660e-03 * h5 + -4.2364845560e-03 * h6 + -8.5939113271e-04 * h7 + 2.5090864151e-03 * h8 + -4.8585659866e-03 * h9 + -2.7112789785e-02 * h10 + -4.6438537155e-03 * h11 + -1.1678200436e-02 * h12 + 3.3943770020e-03 * h13 + 1.4741266455e-03 * h14 + 1.0015816084e-03 * h15 + -2.3766256377e-04 * h16 + -1.6887281848e-03 * h17 + -4.0681006889e-03 * h18 + 5.1996557076e-03 * h19 + -2.5071307041e-03 * h20 + -3.4995138819e-02 * h21 + -2.5842212451e-02 * h22 + 1.5699087232e-03 * h23 + -3.8512937177e-02 * h24 + -1.4656562981e-02 * h25 + -6.7955106523e-03 * h26 + -2.1642334702e-02 * h27 + -4.3521694765e-03 * h28 + 4.3854732947e-02 * h29 + 2.0028558151e-02 * h30 + 5.1611220709e-02 * h31);
    k3 = tanh(3.2285766213e-02 + -4.5087785890e-02 * h0 + 1.6236334647e-02 * h1 + -2.2711668465e-02 * h2 + -2.9926403400e-02 * h3 + 7.4854804680e-02 * h4 + -6.2445962660e-02 * h5 + -4.6370308833e-02 * h6 + -6.8618419452e-02 * h7 + -7.7210737438e-02 * h8 + -1.1610612418e-01 * h9 + 6.7807232868e-02 * h10 + -7.9381546305e-03 * h11 + 1.4797887182e-01 * h12 + -6.6937451732e-02 * h13 + -8.2611998302e-02 * h14 + -1.2270397125e-01 * h15 + -4.3651370713e-03 * h16 + -1.3361927229e-02 * h17 + -3.2722319962e-02 * h18 + 2.1595858476e-02 * h19 + 4.7697070081e-03 * h20 + -1.6239063966e-01 * h21 + -1.3530486946e-01 * h22 + 5.0401803075e-02 * h23 + 9.3614315170e-02 * h24 + -1.0603926992e-01 * h25 + -8.3513700165e-02 * h26 + -5.7329811610e-02 * h27 + -2.7269632325e-01 * h28 + -1.9002394377e-02 * h29 + 1.0439009391e-01 * h30 + 9.7714718380e-02 * h31);
    k4 = tanh(1.4574545292e-01 + -1.6089051521e-01 * h0 + -1.4509619346e-02 * h1 + 8.9048446810e-02 * h2 + 7.5662690082e-02 * h3 + 1.5773089159e-01 * h4 + 6.0174262045e-02 * h5 + 5.0651803765e-02 * h6 + -1.1276795101e-01 * h7 + -8.6887220489e-02 * h8 + 2.8535855531e-03 * h9 + 1.0663528720e-01 * h10 + 1.4080630197e-02 * h11 + 1.9098751312e-02 * h12 + -9.1628828441e-03 * h13 + -8.6562898759e-02 * h14 + 4.7975453941e-02 * h15 + -4.2379751979e-01 * h16 + -1.9256393335e-01 * h17 + -4.7758012195e-02 * h18 + 9.2882972362e-02 * h19 + 7.6478206436e-02 * h20 + 1.3406589043e-01 * h21 + 7.3611014426e-02 * h22 + -3.1148307352e-03 * h23 + -1.6672332269e-01 * h24 + 2.1117667203e-01 * h25 + 1.1640874967e-01 * h26 + -6.3289369871e-03 * h27 + 1.5581262989e-01 * h28 + -1.9290415832e-01 * h29 + 6.2845695280e-02 * h30 + -1.0449685552e-01 * h31);
    k5 = tanh(-1.5802803402e-01 + -5.7376330304e-02 * h0 + 6.3493228803e-02 * h1 + 2.2789566554e-02 * h2 + 1.8226977807e-02 * h3 + 4.0041549151e-03 * h4 + -5.0701474652e-02 * h5 + 4.4284601283e-02 * h6 + -3.1989804136e-02 * h7 + -3.3020751175e-03 * h8 + -1.2057038826e-01 * h9 + 1.2491347235e-01 * h10 + -5.2607472598e-02 * h11 + 1.3532528760e-01 * h12 + 2.6797289946e-02 * h13 + -2.4532095589e-02 * h14 + -4.2854190254e-02 * h15 + 2.9693555222e-02 * h16 + 9.1368388326e-02 * h17 + -4.2890640933e-02 * h18 + -6.5706402877e-02 * h19 + 1.3411892562e-02 * h20 + -1.8746265327e-01 * h21 + -8.7834890135e-02 * h22 + -9.7082158817e-02 * h23 + 2.0512787478e-01 * h24 + -9.5826535274e-02 * h25 + -6.2267347967e-02 * h26 + 5.7814098471e-02 * h27 + -1.2323493221e-01 * h28 + -2.4171389304e-02 * h29 + 6.4320930568e-02 * h30 + 1.2281913719e-01 * h31);
    k6 = tanh(9.2627501290e-02 + -1.8308921328e-02 * h0 + 3.7141784223e-02 * h1 + -4.7526235372e-02 * h2 + -3.4324553738e-02 * h3 + -9.6397973866e-02 * h4 + 1.2143664701e-01 * h5 + -1.3441795528e-02 * h6 + 8.8643913913e-02 * h7 + 5.6137280131e-03 * h8 + 1.2816259383e-01 * h9 + -3.7844386696e-02 * h10 + -3.7630921671e-02 * h11 + -1.1773490201e-02 * h12 + -1.4367008477e-02 * h13 + 4.4245545563e-02 * h14 + 4.5758326036e-02 * h15 + -2.0404050054e-02 * h16 + 5.5655354182e-03 * h17 + 6.2199468925e-02 * h18 + -9.4389982877e-02 * h19 + -6.7775977351e-03 * h20 + 1.3739939323e-01 * h21 + 1.0692036768e-01 * h22 + 9.5682970590e-02 * h23 + -2.1014245123e-01 * h24 + 1.7048495611e-01 * h25 + -8.5592327110e-03 * h26 + 5.2237976956e-02 * h27 + 1.6074907801e-01 * h28 + 2.4523830056e-05 * h29 + -7.5038068364e-02 * h30 + 1.9176645510e-02 * h31);
    k7 = tanh(6.8234161688e-02 + 1.4849198737e-02 * h0 + -3.3762016266e-02 * h1 + 4.4761195839e-03 * h2 + -2.9901838350e-02 * h3 + 9.3028023743e-02 * h4 + -6.0712533237e-02 * h5 + 7.0467758087e-02 * h6 + -3.7417855423e-03 * h7 + -9.2844117921e-03 * h8 + -1.1922291399e-01 * h9 + 1.1703689500e-02 * h10 + -1.0124008362e-01 * h11 + 7.3927678163e-02 * h12 + -6.7053525852e-02 * h13 + -2.4367406053e-02 * h14 + -4.7403586072e-02 * h15 + -3.1208428125e-02 * h16 + -5.6655719151e-02 * h17 + -6.9642274188e-02 * h18 + -5.8051965776e-02 * h19 + 2.8141129725e-03 * h20 + -8.6278127639e-02 * h21 + -5.7817564383e-02 * h22 + -2.4285705433e-02 * h23 + 2.1805549542e-01 * h24 + -4.6037017152e-02 * h25 + -6.0393754504e-03 * h26 + 2.5087751277e-02 * h27 + -8.4978361230e-02 * h28 + 8.2650397166e-02 * h29 + 5.9824753654e-02 * h30 + 1.2668128560e-03 * h31);
    k8 = tanh(-5.5889326269e-02 + -6.5229579463e-03 * h0 + -4.2115323005e-03 * h1 + 9.8533012403e-03 * h2 + 3.7455738551e-02 * h3 + 9.6578225267e-02 * h4 + -6.1399595381e-02 * h5 + -4.0106598196e-02 * h6 + -2.3434988117e-02 * h7 + 1.3489509990e-02 * h8 + -2.7167189598e-02 * h9 + 4.8287378911e-02 * h10 + -7.9521738242e-02 * h11 + 1.0302663738e-01 * h12 + -6.7363464720e-02 * h13 + -2.8795663246e-02 * h14 + -5.1650272696e-02 * h15 + 3.1469691414e-02 * h16 + 1.4283550313e-03 * h17 + -5.2377741025e-02 * h18 + 6.6330198332e-02 * h19 + -1.0455740250e-02 * h20 + -1.7609764288e-01 * h21 + -1.1946151505e-01 * h22 + -8.8014879015e-02 * h23 + 8.7316268581e-02 * h24 + -1.1720072982e-01 * h25 + -7.3379726733e-02 * h26 + -7.5426964567e-02 * h27 + -1.0947137443e-01 * h28 + 4.6173914894e-02 * h29 + -5.9034707178e-02 * h30 + 8.3271823805e-02 * h31);
    k9 = tanh(5.2217371604e-02 + 1.3324953232e-02 * h0 + 1.0155265342e-02 * h1 + 8.7448950153e-02 * h2 + -5.6799582504e-02 * h3 + -9.1783364004e-02 * h4 + -3.6397801737e-02 * h5 + -3.4717488657e-02 * h6 + 4.6034190718e-02 * h7 + -8.9079294973e-02 * h8 + 4.9923062992e-02 * h9 + 7.0206013245e-02 * h10 + -4.6754125908e-03 * h11 + -5.2967692882e-02 * h12 + -1.0542210471e-01 * h13 + 8.5429435326e-02 * h14 + 1.0585853806e-01 * h15 + -4.5250999682e-04 * h16 + -1.6373501378e-02 * h17 + 7.7962513256e-02 * h18 + 4.1538503354e-02 * h19 + -3.0420803962e-02 * h20 + 1.4757123258e-01 * h21 + 2.8868867318e-02 * h22 + -1.9412001783e-02 * h23 + -2.4502296548e-03 * h24 + 4.7829270250e-02 * h25 + 6.1920793097e-03 * h26 + 1.1168379761e-01 * h27 + 1.2620402283e-01 * h28 + -1.4383401194e-01 * h29 + -1.1555692902e-01 * h30 + -1.3635780498e-01 * h31);
    k10 = tanh(1.7101654796e-01 + -2.0160771713e-02 * h0 + 1.0827558558e-02 * h1 + -4.8116602000e-02 * h2 + 5.6805072106e-02 * h3 + -6.9020266344e-02 * h4 + 9.9312942023e-02 * h5 + -1.4917711591e-02 * h6 + 2.1005158584e-02 * h7 + 9.1096905219e-02 * h8 + -1.3079014764e-02 * h9 + -6.8304812054e-02 * h10 + 6.5517895807e-02 * h11 + 7.6491876023e-02 * h12 + -3.8330609597e-02 * h13 + 2.9757275150e-02 * h14 + 3.2510142948e-02 * h15 + -1.7685163367e-02 * h16 + -3.6416835225e-02 * h17 + 2.3672673803e-02 * h18 + -9.4792907633e-02 * h19 + -2.7787193775e-02 * h20 + 1.1133424106e-01 * h21 + -7.0228049777e-02 * h22 + 3.6113238310e-02 * h23 + -8.8307595236e-02 * h24 + 6.1846300633e-02 * h25 + 1.0786274244e-01 * h26 + -3.7371868941e-03 * h27 + 6.7765919817e-02 * h28 + -1.7667389835e-01 * h29 + -5.7357526535e-02 * h30 + -1.0381175691e-01 * h31);
    k11 = tanh(3.3820758465e-02 + -2.1472226460e-02 * h0 + 7.8019998838e-03 * h1 + 1.6231018624e-03 * h2 + -1.0181814361e-02 * h3 + 5.2231778964e-02 * h4 + 4.7689876707e-03 * h5 + 1.5093506063e-03 * h6 + -4.3442186935e-02 * h7 + 2.7158390553e-03 * h8 + -1.0558958619e-01 * h9 + -3.2967932110e-02 * h10 + -6.4503178681e-03 * h11 + 5.6872774927e-02 * h12 + 4.4088122174e-02 * h13 + -4.8703338243e-02 * h14 + -5.7995068888e-02 * h15 + 9.3588318012e-03 * h16 + -3.9870227289e-03 * h17 + -5.1330974915e-02 * h18 + 6.7420084386e-02 * h19 + 6.0451910764e-02 * h20 + -9.9339302802e-02 * h21 + -1.9360826173e-02 * h22 + -5.1664598188e-03 * h23 + 1.5199330188e-01 * h24 + -4.8086573978e-02 * h25 + -1.2289755458e-02 * h26 + 2.4432651848e-02 * h27 + -1.5822226144e-01 * h28 + -4.6419816514e-02 * h29 + 3.5062062893e-02 * h30 + 1.4403956854e-01 * h31);
    k12 = tanh(7.0927850001e-02 + 1.1832037096e-01 * h0 + -5.8983128860e-02 * h1 + 4.1808279877e-02 * h2 + -4.4625469128e-02 * h3 + -3.8092565401e-02 * h4 + 3.5369581485e-02 * h5 + 1.5422979052e-02 * h6 + 1.3827078270e-01 * h7 + -3.0404120137e-02 * h8 + 1.0059099293e-01 * h9 + 8.2818734638e-02 * h10 + 4.0120356329e-02 * h11 + 1.1627269850e-02 * h12 + -8.7963812623e-02 * h13 + 6.5460550502e-02 * h14 + 1.1844527775e-01 * h15 + 1.0324159955e-03 * h16 + -4.3148263583e-03 * h17 + 8.2910319917e-02 * h18 + 4.7673615399e-02 * h19 + 2.5079264276e-02 * h20 + 2.2988683847e-01 * h21 + 1.1643227026e-01 * h22 + 7.6104131028e-03 * h23 + -9.1991610929e-02 * h24 + -5.9863065110e-03 * h25 + 8.9135316943e-02 * h26 + -3.9794318711e-02 * h27 + 1.1169047035e-01 * h28 + -9.2846711984e-02 * h29 + -1.2498570169e-01 * h30 + -1.3915152106e-01 * h31);
    k13 = tanh(-3.8995441917e-02 + -1.3917038309e-02 * h0 + -3.1283673768e-02 * h1 + 7.0770806309e-02 * h2 + 8.7926338386e-02 * h3 + 8.9505784802e-02 * h4 + 2.7489157444e-02 * h5 + -9.1694036453e-02 * h6 + -7.3708436823e-03 * h7 + -1.0280631400e-01 * h8 + -1.2637975284e-01 * h9 + -1.0635067392e-01 * h10 + 7.7158584419e-03 * h11 + -1.0072680668e-01 * h12 + -5.3911404804e-02 * h13 + -8.5693203157e-02 * h14 + -1.3066918252e-01 * h15 + 2.9896675914e-03 * h16 + 1.1117808184e-01 * h17 + -4.6951343438e-02 * h18 + 4.0188200572e-02 * h19 + -3.4391754187e-02 * h20 + -3.3581827687e-02 * h21 + -6.1943927062e-02 * h22 + -1.3216520810e-01 * h23 + 1.9452885718e-01 * h24 + -1.0437333630e-01 * h25 + 5.1431237662e-02 * h26 + -1.0191084165e-01 * h27 + -2.4960831870e-01 * h28 + -6.5688808454e-02 * h29 + 1.0067736375e-01 * h30 + 6.6437156824e-02 * h31);
    k14 = tanh(-9.4696169125e-02 + -6.1118834177e-02 * h0 + 3.6402837498e-02 * h1 + -1.2795577863e-02 * h2 + 3.6992589741e-02 * h3 + -4.1096002358e-02 * h4 + -9.4123666928e-02 * h5 + 1.0141285217e-01 * h6 + -6.9841620141e-02 * h7 + 4.9183311777e-02 * h8 + -1.0396842010e-02 * h9 + -7.4319544629e-02 * h10 + -9.5648298171e-02 * h11 + 3.3092591148e-02 * h12 + -7.8222678357e-02 * h13 + -5.5683395013e-02 * h14 + -1.1265509423e-01 * h15 + 2.5419795574e-02 * h16 + -3.1949273177e-02 * h17 + -1.6919997317e-02 * h18 + -3.8758864445e-02 * h19 + 5.2445469287e-03 * h20 + -1.2927516874e-01 * h21 + -9.7363208262e-02 * h22 + -1.1791081439e-01 * h23 + 1.5142666966e-01 * h24 + -8.7183252344e-02 * h25 + -2.3817163048e-02 * h26 + 8.6743999876e-02 * h27 + -2.3580880332e-01 * h28 + -2.1002435591e-02 * h29 + -3.0257978872e-02 * h30 + 1.3841502007e-01 * h31);
    k15 = tanh(-1.1775356618e-01 + -3.5387689726e-02 * h0 + 7.7205048604e-03 * h1 + 3.3149000650e-02 * h2 + 5.1663091452e-02 * h3 + 9.5595675722e-02 * h4 + -8.6226653509e-02 * h5 + -1.5328094447e-04 * h6 + -5.6531062903e-02 * h7 + 5.4908289328e-02 * h8 + -9.5719150392e-02 * h9 + -4.8900341245e-02 * h10 + -4.6992233737e-02 * h11 + 5.1608951125e-03 * h12 + 4.1084158025e-02 * h13 + -3.7778094385e-02 * h14 + -1.1544757975e-01 * h15 + 3.1227804057e-02 * h16 + 6.6892675835e-02 * h17 + -3.0457912288e-02 * h18 + -6.0233435124e-02 * h19 + 2.6445760174e-02 * h20 + -7.6783480512e-02 * h21 + 2.3829056360e-02 * h22 + -5.0730844076e-02 * h23 + 1.1445746461e-01 * h24 + -1.0707396617e-01 * h25 + -3.6358235438e-03 * h26 + 1.0446876087e-01 * h27 + -1.3326567958e-01 * h28 + -2.1957739536e-02 * h29 + 8.7362620321e-02 * h30 + 1.1401806502e-01 * h31);
    k16 = tanh(2.6355373794e-01 + 1.0922182986e-01 * h0 + -1.1327497220e-01 * h1 + 2.5272607042e-01 * h2 + -4.4794848414e-02 * h3 + -2.4985392778e-01 * h4 + 4.1032100325e-02 * h5 + 5.1888913760e-01 * h6 + 1.5644930341e-01 * h7 + -3.5274464411e-01 * h8 + 5.3072596486e-01 * h9 + 2.2883665313e-01 * h10 + 1.4029937175e-01 * h11 + 1.1447991918e-01 * h12 + -1.8572495502e-01 * h13 + 1.4313079977e-01 * h14 + 3.1314498177e-01 * h15 + 3.4014936089e-02 * h16 + -1.9827418202e-01 * h17 + 6.4137304312e-01 * h18 + 3.5658365002e-01 * h19 + -7.1866788682e-03 * h20 + 3.8894884657e-01 * h21 + 4.3044918828e-02 * h22 + -2.9339185832e-01 * h23 + -2.1444539638e-01 * h24 + 3.1130244461e-02 * h25 + 8.8864264182e-02 * h26 + -8.1693169654e-02 * h27 + -4.1017970201e-02 * h28 + 2.4264998225e-02 * h29 + -6.0361500747e-01 * h30 + -1.1698965877e-01 * h31);
    k17 = tanh(4.4925172694e-02 + 6.1896553235e-03 * h0 + 9.0845204081e-03 * h1 + -2.3166018034e-02 * h2 + 8.2642392198e-03 * h3 + -7.2297882910e-02 * h4 + 9.1317762667e-02 * h5 + 7.1632889700e-02 * h6 + 2.9690347705e-02 * h7 + 1.1767708948e-02 * h8 + 4.6141386725e-02 * h9 + -4.2906076357e-02 * h10 + -1.2966734756e-02 * h11 + -5.2990613145e-02 * h12 + 1.9443714246e-04 * h13 + 2.0324192513e-02 * h14 + 5.2682244858e-02 * h15 + -1.2188532195e-02 * h16 + -2.2428647670e-03 * h17 + 1.7898683309e-02 * h18 + -5.1840513798e-02 * h19 + -2.3717991715e-02 * h20 + 1.0714607518e-01 * h21 + -6.8312541925e-02 * h22 + 2.8027490217e-02 * h23 + -6.3199675634e-02 * h24 + 8.5819860880e-02 * h25 + 3.1864649835e-02 * h26 + 4.4552747187e-02 * h27 + 1.3127030271e-01 * h28 + -7.3810749583e-02 * h29 + -1.4284319577e-02 * h30 + -1.4667709175e-01 * h31);
    k18 = tanh(1.2895945423e-01 + -2.7127421605e-02 * h0 + 1.9989354799e-02 * h1 + 5.0321685613e-02 * h2 + 4.5283074354e-02 * h3 + -5.9952351897e-02 * h4 + -1.9416185901e-02 * h5 + 7.0680876295e-02 * h6 + -9.8056631350e-02 * h7 + -7.5088554229e-02 * h8 + -1.2507726373e-01 * h9 + 1.2613373074e-02 * h10 + -6.6688563909e-02 * h11 + 3.6890832572e-02 * h12 + 8.8733740138e-03 * h13 + -7.2794558103e-02 * h14 + -8.3009454642e-03 * h15 + 4.5664213575e-02 * h16 + 6.6209076722e-02 * h17 + 5.9283393389e-02 * h18 + 3.2284589573e-02 * h19 + 1.7159019522e-01 * h20 + -8.6845288426e-02 * h21 + -9.7695853156e-02 * h22 + 3.5757291210e-03 * h23 + 5.9363583998e-02 * h24 + -6.0465735618e-02 * h25 + 4.5654460365e-02 * h26 + -2.9464798914e-02 * h27 + -2.1084328883e-01 * h28 + -1.1188911260e-03 * h29 + -1.0801470685e-02 * h30 + 1.4294723802e-01 * h31);
    k19 = tanh(1.4941185696e-01 + 5.4135253378e-02 * h0 + -6.6865463039e-02 * h1 + 5.7127553378e-02 * h2 + -3.1728765372e-02 * h3 + 1.2542473164e-01 * h4 + -1.1665933063e-01 * h5 + 8.9905944372e-03 * h6 + 3.1180270465e-02 * h7 + 1.9953119970e-02 * h8 + -9.3121878841e-02 * h9 + -8.7246115106e-02 * h10 + -6.4164895841e-02 * h11 + 9.9734509345e-02 * h12 + -9.5768640783e-02 * h13 + 1.9631255588e-02 * h14 + -5.1935250323e-02 * h15 + 1.6196651117e-02 * h16 + 2.4355487492e-02 * h17 + -6.2858103780e-02 * h18 + -2.3025693985e-02 * h19 + -6.4475369722e-02 * h20 + -8.8899249567e-02 * h21 + -6.0742990996e-02 * h22 + 9.9918801886e-03 * h23 + 2.3687244985e-02 * h24 + -1.8814502410e-01 * h25 + -4.9560864568e-02 * h26 + -7.6719425420e-02 * h27 + -7.9578152357e-02 * h28 + 6.9688444823e-02 * h29 + -3.4031774724e-02 * h30 + 1.2041501238e-01 * h31);
    k20 = tanh(-5.6005946868e-02 + 1.1054197154e-02 * h0 + 2.5465120367e-02 * h1 + -2.6364505212e-02 * h2 + -7.9121798271e-02 * h3 + -2.8008882212e-03 * h4 + 9.9795882326e-02 * h5 + -1.4293795300e-01 * h6 + 1.0185357549e-01 * h7 + 6.1811745518e-02 * h8 + 8.8077086966e-02 * h9 + -6.3808579407e-03 * h10 + 1.5336152492e-02 * h11 + -1.4405873464e-01 * h12 + 2.2912617889e-02 * h13 + 4.9253842633e-02 * h14 + -1.1446672082e-02 * h15 + -5.8333252791e-03 * h16 + -8.8236684553e-02 * h17 + 5.1187998819e-02 * h18 + 6.6334121836e-02 * h19 + -2.2999194881e-02 * h20 + 3.2593832840e-02 * h21 + 1.0742903161e-01 * h22 + 1.2351661569e-01 * h23 + -1.0742730598e-01 * h24 + 1.2303243363e-01 * h25 + 7.9093259256e-02 * h26 + 1.1551938081e-01 * h27 + 2.2381233726e-01 * h28 + -6.5971565816e-03 * h29 + -8.3607143908e-02 * h30 + -1.5882930084e-01 * h31);
    k21 = tanh(-1.8728716618e-01 + -1.6198096391e-01 * h0 + 4.3014759405e-01 * h1 + -3.2929892334e-01 * h2 + 1.5116731293e-01 * h3 + -2.0395426290e-01 * h4 + 1.0536076618e-02 * h5 + -5.0336188490e-01 * h6 + 1.5708502249e-01 * h7 + 1.7230223710e-01 * h8 + 4.2474774866e-01 * h9 + -1.5557288739e-02 * h10 + 2.8384232505e-01 * h11 + -3.8628120894e-01 * h12 + 4.7163366803e-01 * h13 + 1.7989748478e-02 * h14 + -7.0924271313e-02 * h15 + 8.3057097551e-02 * h16 + 2.1187277896e-01 * h17 + -2.2241041285e-01 * h18 + 7.0968935141e-03 * h19 + 3.1446908262e-01 * h20 + 9.9238075322e-02 * h21 + -1.2127611708e-01 * h22 + -2.5728789261e-01 * h23 + -2.0994272744e-01 * h24 + 4.8740994609e-01 * h25 + -3.2019772674e-01 * h26 + 1.4606672295e-03 * h27 + 2.3185933990e-01 * h28 + -5.8426885558e-01 * h29 + 1.7063911701e-01 * h30 + 1.0316206341e-01 * h31);
    k22 = tanh(-5.4677036046e-02 + 9.7173741424e-02 * h0 + 1.4095141221e-01 * h1 + -5.0562369906e-02 * h2 + -8.7867179045e-02 * h3 + -4.4750232220e-02 * h4 + 9.0092826187e-02 * h5 + -1.7545911052e-01 * h6 + 3.2310219615e-01 * h7 + 9.5713123209e-02 * h8 + 9.4789144488e-02 * h9 + -3.5763617003e-02 * h10 + 1.1555787750e-01 * h11 + -1.6306312162e-01 * h12 + 9.2124880543e-02 * h13 + 3.1383882941e-01 * h14 + 1.5410479918e-01 * h15 + -1.8144843117e-02 * h16 + -1.6289177526e-01 * h17 + -2.6264724172e-01 * h18 + -6.2713167548e-02 * h19 + -3.4597885185e-01 * h20 + 1.7123919617e-01 * h21 + 1.3732166316e-01 * h22 + -3.7085484350e-02 * h23 + -1.1998807830e-01 * h24 + 2.3378492376e-01 * h25 + -2.5451178996e-01 * h26 + -5.8608313057e-02 * h27 + 4.1723758977e-01 * h28 + 2.6661003077e-02 * h29 + 7.9721537337e-02 * h30 + -1.1668224358e-01 * h31);
    k23 = tanh(1.5083434520e-02 + -3.6501056278e-02 * h0 + -4.1516236768e-02 * h1 + -1.0297827261e-01 * h2 + -9.0446667345e-02 * h3 + 9.8048064167e-02 * h4 + 1.1860590726e-01 * h5 + 5.5040632620e-03 * h6 + 2.6529505435e-02 * h7 + 1.2099118721e-01 * h8 + 5.4117891997e-02 * h9 + 9.1665153130e-02 * h10 + 6.5909121798e-02 * h11 + -1.1520915018e-01 * h12 + 6.2999936865e-03 * h13 + 9.0612040909e-03 * h14 + -5.2087158493e-02 * h15 + -2.7056691739e-02 * h16 + -3.7482236232e-02 * h17 + 5.6493400685e-02 * h18 + 4.2990858780e-02 * h19 + 2.3410402523e-03 * h20 + 1.7850376076e-01 * h21 + 3.4978823333e-02 * h22 + 1.0542896550e-01 * h23 + -2.0463847809e-01 * h24 + 8.5839820992e-02 * h25 + 1.0482827124e-02 * h26 + 1.0474657211e-01 * h27 + 4.5659824939e-02 * h28 + -1.7298058933e-01 * h29 + 1.9729268635e-03 * h30 + 6.2982953289e-02 * h31);
    k24 = tanh(8.1357271723e-02 + -5.7003192090e-04 * h0 + 2.6099817132e-03 * h1 + -3.2129314859e-03 * h2 + 3.4866332611e-03 * h3 + -7.2176802408e-03 * h4 + -1.8276718793e-02 * h5 + -7.6563852879e-03 * h6 + -2.5233039756e-04 * h7 + 3.9114424728e-03 * h8 + -2.7479294160e-03 * h9 + -1.5021321898e-02 * h10 + 3.5078733102e-03 * h11 + -1.4811369830e-02 * h12 + 6.4987064864e-03 * h13 + 1.5499739657e-03 * h14 + 3.3750032145e-03 * h15 + -9.1148168339e-05 * h16 + -1.3804757951e-03 * h17 + -3.6592885074e-03 * h18 + -7.3344786380e-04 * h19 + -2.9010457047e-03 * h20 + -2.3749778700e-02 * h21 + -1.9390648398e-02 * h22 + 2.3482489681e-03 * h23 + -1.4528244501e-03 * h24 + -2.4965053135e-04 * h25 + -5.4037089452e-03 * h26 + -7.5336890601e-03 * h27 + 3.6394739128e-04 * h28 + -9.9108330447e-03 * h29 + 1.2138949313e-03 * h30 + -5.8933370005e-03 * h31);
    k25 = tanh(1.4534190418e-01 + 2.6665548908e-02 * h0 + -2.2722607742e-02 * h1 + 4.6243743939e-02 * h2 + -5.7901212762e-02 * h3 + -1.2730096726e-01 * h4 + 3.6989068147e-02 * h5 + -5.5394112505e-02 * h6 + 2.8667942208e-02 * h7 + 7.1887147472e-02 * h8 + 1.1972254924e-01 * h9 + 7.1690050929e-02 * h10 + 1.1695253925e-03 * h11 + -1.2059164379e-01 * h12 + 3.2286853809e-03 * h13 + 4.8119767188e-02 * h14 + 1.0040566547e-01 * h15 + -5.1002613171e-02 * h16 + 4.5006952391e-02 * h17 + 1.1251319192e-02 * h18 + 1.0430320173e-01 * h19 + 9.3054706640e-03 * h20 + 1.9049116908e-01 * h21 + 1.2649520536e-01 * h22 + 5.9898381408e-02 * h23 + -9.8613711471e-02 * h24 + 6.3155770708e-02 * h25 + 3.4009979944e-02 * h26 + -1.0318571772e-01 * h27 + 2.7074964092e-01 * h28 + -3.7000484563e-02 * h29 + 1.9618967584e-02 * h30 + -8.4390351092e-02 * h31);
    k26 = tanh(-4.2712559251e-02 + 3.1126538717e-04 * h0 + -1.1747331575e-03 * h1 + 1.3567814926e-03 * h2 + -9.6548774495e-04 * h3 + 2.7782766020e-03 * h4 + 3.1695611333e-03 * h5 + 3.4899033445e-03 * h6 + 1.9953370207e-04 * h7 + -1.7095642451e-03 * h8 + 1.1204910952e-03 * h9 + 3.1755635172e-03 * h10 + -2.2993381403e-03 * h11 + 4.5486496343e-03 * h12 + -1.8161632491e-03 * h13 + -6.5946419670e-04 * h14 + -1.6122419875e-03 * h15 + 7.0797261080e-05 * h16 + 6.4733343518e-04 * h17 + 1.7484808609e-03 * h18 + 1.5728586249e-03 * h19 + 1.3242005143e-03 * h20 + 5.2397758158e-03 * h21 + 4.7663976600e-03 * h22 + -9.7944427276e-04 * h23 + 6.8218527702e-03 * h24 + -3.3231773642e-03 * h25 + 2.8535595687e-03 * h26 + 9.0917833479e-04 * h27 + -9.4490943591e-04 * h28 + 7.0096281851e-03 * h29 + -3.5713073110e-03 * h30 + -5.9406519453e-03 * h31);
    k27 = tanh(-1.0494097495e-01 + -1.4390971052e-01 * h0 + 4.9450821513e-02 * h1 + 6.4252183429e-02 * h2 + 1.4351444669e-01 * h3 + -1.2328838044e-01 * h4 + -4.0477082526e-02 * h5 + 7.7581506194e-02 * h6 + -1.3851570108e-01 * h7 + -2.0460775440e-01 * h8 + 2.6713613912e-02 * h9 + 5.4145013167e-02 * h10 + 4.2751964095e-02 * h11 + -1.6994409780e-02 * h12 + 2.4966454862e-02 * h13 + -3.3870131432e-01 * h14 + 1.7191540663e-01 * h15 + -3.1171247863e-01 * h16 + -9.5897684523e-02 * h17 + 2.5172040281e-01 * h18 + 2.9306252454e-01 * h19 + 2.7302824518e-01 * h20 + 2.8555391589e-02 * h21 + -1.4974527991e-01 * h22 + -7.9381121357e-02 * h23 + -3.2860967327e-01 * h24 + 2.5074498177e-01 * h25 + 1.7354808960e-01 * h26 + 7.0763098929e-02 * h27 + -2.8416071048e-02 * h28 + -1.9184730866e-01 * h29 + -8.7796945535e-02 * h30 + -2.2074208205e-02 * h31);
    k28 = tanh(-1.3282222450e-01 + -8.7897011004e-02 * h0 + 2.0461575617e-01 * h1 + 3.0816943091e-03 * h2 + 3.2796927989e-02 * h3 + -1.6263820104e-02 * h4 + -8.2584015696e-03 * h5 + -1.6663357777e-01 * h6 + 7.3644984106e-02 * h7 + -5.8167901166e-02 * h8 + 2.0756768440e-01 * h9 + 1.0934184313e-01 * h10 + 1.6751187766e-01 * h11 + -1.9819375174e-01 * h12 + 1.4866721409e-01 * h13 + -7.5050255662e-02 * h14 + -3.3456815512e-02 * h15 + -2.1034606866e-01 * h16 + -1.5123645291e-02 * h17 + -1.0369756597e-01 * h18 + 7.2648147363e-02 * h19 + -7.3147499924e-02 * h20 + 2.6474446492e-01 * h21 + 1.6097114753e-01 * h22 + -6.4029008654e-02 * h23 + -7.0899172962e-02 * h24 + 1.0629964501e-01 * h25 + -1.3055403457e-01 * h26 + -6.9589340817e-02 * h27 + 2.1562898478e-01 * h28 + -2.2204023958e-01 * h29 + -8.7295499183e-02 * h30 + -4.7550587005e-02 * h31);
    k29 = tanh(-1.9291443556e-01 + -1.6294856922e-01 * h0 + 6.0038503818e-02 * h1 + -6.2219691471e-02 * h2 + 1.6097009574e-02 * h3 + 1.5812278447e-01 * h4 + -3.6603631515e-02 * h5 + -1.2806796656e-01 * h6 + -9.1609531225e-02 * h7 + -1.0440484118e-01 * h8 + 3.6005563911e-02 * h9 + 1.4527781870e-01 * h10 + -9.3242631354e-02 * h11 + -3.3520580848e-02 * h12 + 1.6875229256e-01 * h13 + -2.3088214946e-01 * h14 + -1.5480218705e-01 * h15 + -1.8220650496e-01 * h16 + -1.5537974596e-01 * h17 + -2.1211804882e-01 * h18 + -6.5155895527e-02 * h19 + 1.3373230824e-01 * h20 + -2.6158429708e-01 * h21 + -2.4509758559e-02 * h22 + -1.3911764903e-01 * h23 + 1.6978596234e-01 * h24 + 1.0810420519e-01 * h25 + -1.7791535940e-01 * h26 + -7.5853358188e-02 * h27 + -2.8359511069e-01 * h28 + 2.7579786325e-01 * h29 + 1.4220513967e-01 * h30 + 1.0303871323e-01 * h31);
    k30 = tanh(7.4161841202e-02 + -1.3458483138e-03 * h0 + 2.6809439318e-03 * h1 + 9.7004238462e-03 * h2 + 1.9149533684e-02 * h3 + 1.8684264776e-02 * h4 + -5.9559243339e-04 * h5 + 8.3557673642e-02 * h6 + -1.5477401537e-02 * h7 + -1.1722040123e-02 * h8 + -6.1806768725e-02 * h9 + -1.1335353303e-03 * h10 + 3.0067249743e-02 * h11 + 4.4400183147e-02 * h12 + -7.3541368733e-03 * h13 + -1.8615260725e-02 * h14 + -1.4756701486e-02 * h15 + 1.7591628157e-02 * h16 + 1.9477947356e-02 * h17 + 1.4206037152e-02 * h18 + 3.4668669610e-02 * h19 + 6.3657222263e-02 * h20 + -1.3111575489e-01 * h21 + -6.4634193948e-02 * h22 + -1.5994779461e-02 * h23 + -3.3105831436e-02 * h24 + -6.5474731686e-02 * h25 + 1.1327271542e-02 * h26 + 6.6087148666e-03 * h27 + -1.3005606489e-01 * h28 + 2.9502421290e-02 * h29 + 1.2231333080e-03 * h30 + 9.7270924343e-02 * h31);
    k31 = tanh(-1.2160784929e-01 + -1.4256726374e-02 * h0 + 2.6661260785e-03 * h1 + 1.2269407094e-02 * h2 + -4.8086407066e-03 * h3 + -3.5047937527e-03 * h4 + -5.7280468458e-02 * h5 + 9.9063953292e-03 * h6 + -3.0445941865e-02 * h7 + 2.5794677677e-02 * h8 + -4.7660057153e-02 * h9 + -7.0317772113e-03 * h10 + -4.6794060937e-02 * h11 + -1.8560041682e-02 * h12 + -1.8978234141e-02 * h13 + -2.3014901742e-02 * h14 + -5.9048901695e-02 * h15 + 2.1190868714e-02 * h16 + 2.0353655025e-02 * h17 + -4.8734719135e-03 * h18 + 1.3752542148e-02 * h19 + 1.2210583975e-02 * h20 + -1.4214718252e-01 * h21 + -9.6197263483e-03 * h22 + -5.9172521437e-02 * h23 + 1.0663383733e-01 * h24 + -9.1939310718e-02 * h25 + -3.9857426499e-02 * h26 + -4.1918385593e-02 * h27 + -1.3880474911e-01 * h28 + -2.2481340645e-02 * h29 + 5.2490362372e-02 * h30 + 1.2041828933e-01 * h31);
    acc = -3.4013960252e-02 + -5.1014930902e-02 * k0 + 2.8073991168e-01 * k1 + -9.5746011482e-06 * k2 + 2.0069525912e-01 * k3 + -3.8415544855e-01 * k4 + 1.8013029651e-01 * k5 + -1.5049163681e-01 * k6 + 4.4576767769e-02 * k7 + 1.3423649197e-01 * k8 + -7.0102689866e-02 * k9 + -2.2976375129e-01 * k10 + 1.0748078912e-01 * k11 + -8.5402287087e-02 * k12 + 1.2311217323e-01 * k13 + 1.8063678407e-01 * k14 + 6.7851620109e-02 * k15 + -3.1017962282e-01 * k16 + -3.9677680504e-02 * k17 + 1.1394625937e-01 * k18 + 5.2085565526e-02 * k19 + -1.7191580341e-01 * k20 + -1.8082638642e-01 * k21 + -5.8527720319e-01 * k22 + -9.5826555052e-02 * k23 + -1.5635451329e-04 * k24 + -2.4113008738e-01 * k25 + 3.6484467085e-05 * k26 + -1.1796295850e-01 * k27 + -1.7556222910e-01 * k28 + 5.8579919067e-01 * k29 + 1.3910363208e-02 * k30 + 4.9943041540e-02 * k31;
    gsum = gsum + 1 * tanh(acc);
    // ensemble member 2
    h0 = tanh(2.6528480192e-01 + 8.9067023527e-03 * x0 + -1.7152761142e-01 * x1 + -2.3537225461e-01 * x2 + 7.1863010174e-02 * x3 + 5.0415422916e-01 * x4 + 7.8592850513e-02 * x5);
    h1 = tanh(1.0375208423e-01 + -1.6588495521e-01 * x0 + -3.1856440118e-01 * x1 + 9.3874553994e-02 * x2 + -3.7971519616e-01 * x3 + 1.0662762885e-02 * x4 + 5.6129263966e-03 * x5);
    h2 = tanh(-1.5679084894e-01 + -1.2952954383e-01 * x0 + 3.1026455530e-01 * x1 + 1.3854668713e-02 * x2 + 1.7541499672e-01 * x3 + 1.3569370498e-01 * x4 + -3.3856056375e-01 * x5);
    h3 = tanh(-3.2771639512e-01 + -4.7610832408e-01 * x0 + 3.2895589005e-01 * x1 + -3.7809261048e-01 * x2 + 6.4354995185e-02 * x3 + 1.0447771763e-01 * x4 + 4.4458205201e-01 * x5);
    h4 = tanh(6.1362470766e-02 + -6.2640822856e-02 * x0 + 7.0771083914e-02 * x1 + 1.2459953053e-01 * x2 + -1.5990417126e-01 * x3 + -1.8077668643e-01 * x4 + -1.8233160159e-01 * x5);
    h5 = tanh(-1.7801930260e-01 + -4.1511020375e-01 * x0 + -4.2294710688e-01 * x1 + -6.5430977159e-02 * x2 + -4.2557027135e-02 * x3 + 5.8678075868e-02 * x4 + -2.7436708492e-01 * x5);
    h6 = tanh(1.3848399613e-01 + 1.2923355893e-01 * x0 + -2.2014181365e-01 * x1 + 1.2610731412e-04 * x2 + -1.7267590569e-01 * x3 + -3.0188979157e-02 * x4 + -3.1394248783e-01 * x5);
    h7 = tanh(3.8110958485e-01 + 1.1738825027e-01 * x0 + 3.2142660092e-03 * x1 + 2.8416997924e-01 * x2 + 3.0947275808e-01 * x3 + 2.6562259075e-01 * x4 + 7.4894804995e-02 * x5);
    h8 = tanh(-2.4069555211e-01 + 1.3438564833e-01 * x0 + 1.5193097566e-01 * x1 + 9.7302614831e-02 * x2 + 2.3482788501e-01 * x3 + 1.1196204701e-01 * x4 + 1.9090290935e-01 * x5);
    h9 = tanh(-2.0270331866e-01 + -3.1127819350e-02 * x0 + 1.5661005611e-02 * x1 + -2.7929321098e-01 * x2 + 2.3782054535e-01 * x3 + 4.5719414097e-02 * x4 + 2.9172728450e-01 * x5);
    h10 = tanh(-1.3404097739e-01 + 2.7046650353e-01 * x0 + -2.3917105628e-01 * x1 + 4.9805163975e-02 * x2 + 3.1028009099e-01 * x3 + 7.6788910493e-02 * x4 + 1.7289170065e-03 * x5);
    h11 = tanh(-2.6550466014e-01 + 1.6130289267e-01 * x0 + -1.4745116405e-01 * x1 + -5.5358118610e-02 * x2 + 1.0644880655e-01 * x3 + -2.3921453564e-01 * x4 + 3.3176212391e-01 * x5);
    h12 = tanh(-1.2985029961e-01 + -3.3784660297e-01 * x0 + 1.1719163470e-01 * x1 + -1.3493369417e-01 * x2 + 9.7957105686e-02 * x3 + 5.9649537526e-02 * x4 + -5.9804095082e-01 * x5);
    h13 = tanh(2.4207079339e-01 + -1.1650543328e-01 * x0 + -1.1917816338e-01 * x1 + 4.9010621174e-02 * x2 + 2.0380254867e-01 * x3 + -2.7464683713e-01 * x4 + 2.0155774233e-01 * x5);
    h14 = tanh(1.4584882338e-01 + 2.1311431767e-01 * x0 + -1.9771848396e-01 * x1 + 7.6860887022e-02 * x2 + 2.5810291108e-01 * x3 + -2.8106429313e-01 * x4 + -2.7901980311e-01 * x5);
    h15 = tanh(-6.9176644941e-02 + 9.0136019677e-02 * x0 + -2.8344810933e-01 * x1 + 2.5032730476e-01 * x2 + 6.4129985580e-02 * x3 + 2.9478880750e-01 * x4 + 2.6720380096e-01 * x5);
    h16 = tanh(-2.2365329857e-02 + -1.9113470032e-01 * x0 + -3.0070623402e-02 * x1 + -2.5237367895e-01 * x2 + 8.4249837599e-02 * x3 + -4.5849672808e-01 * x4 + 1.2153011215e-02 * x5);
    h17 = tanh(-1.5308691642e-01 + -2.9163921817e-01 * x0 + -1.8032565522e-02 * x1 + 7.1174707808e-02 * x2 + 9.7617723455e-03 * x3 + 1.1092156982e-01 * x4 + 6.7346898079e-01 * x5);
    h18 = tanh(-2.8631652624e-01 + -3.7698147968e-01 * x0 + 1.2858835026e-01 * x1 + 3.0959652735e-01 * x2 + -2.7470476055e-01 * x3 + -1.0601685001e-01 * x4 + 1.7879905053e-01 * x5);
    h19 = tanh(-1.9522759380e-01 + -1.8735763424e-01 * x0 + 2.5948545712e-02 * x1 + -3.6129580754e-01 * x2 + 2.5040686964e-01 * x3 + -2.2526237553e-01 * x4 + 2.4052846211e-01 * x5);
    h20 = tanh(-7.3416484208e-02 + 2.9121243688e-01 * x0 + 2.2718400336e-01 * x1 + -2.0789730555e-01 * x2 + 7.1382956634e-02 * x3 + 4.5208614278e-02 * x4 + -8.0770660171e-01 * x5);
    h21 = tanh(-1.7777520141e-01 + -6.9872833366e-01 * x0 + 2.1788133533e-01 * x1 + -6.6578161759e-01 * x2 + -3.3731955055e-01 * x3 + -1.0116760341e+00 * x4 + 6.6020027502e-02 * x5);
    h22 = tanh(-2.6801256596e-01 + -2.9512180400e-01 * x0 + -3.5626145447e-01 * x1 + -6.8835422719e-02 * x2 + 6.6304252633e-02 * x3 + 7.1221644023e-02 * x4 + -2.6060341619e-01 * x5);
    h23 = tanh(7.2847189221e-02 + 5.0096022450e-01 * x0 + -1.1875465779e-01 * x1 + -3.9044521611e-01 * x2 + -1.2851771900e-01 * x3 + 3.6998416735e-03 * x4 + -7.9223675914e-02 * x5);
    h24 = tanh(-5.2539525561e-02 + -1.1187498264e-01 * x0 + 2.3813955858e-01 * x1 + -3.6312191730e-01 * x2 + 4.3905497435e-01 * x3 + 3.0044118773e-01 * x4 + -1.9039334541e-01 * x5);
    h25 = tanh(-3.8540499057e-01 + -7.7528129883e-02 * x0 + -2.1850620462e-01 * x1 + -2.8316172066e-01 * x2 + 4.9793446460e-02 * x3 + 9.4471333183e-02 * x4 + -1.0662576205e+00 * x5);
    h26 = tanh(7.4114596308e-02 + -1.2883184863e-01 * x0 + -8.7339691048e-02 * x1 + 5.4133475450e-01 * x2 + 2.6604890063e-01 * x3 + -3.2590331962e-01 * x4 + 4.7985448175e-01 * x5);
    h27 = tanh(5.0590095716e-01 + 1.6396566211e-01 * x0 + -4.7097502007e-01 * x1 + 1.5789102083e-01 * x2 + 1.6771465974e-01 * x3 + 3.3262238271e-02 * x4 + -6.0379642096e-02 * x5);
    h28 = tanh(3.7832769586e-02 + -1.6452403473e-01 * x0 + -2.5448086957e-01 * x1 + -3.8166723008e-01 * x2 + 1.1024223023e-01 * x3 + 2.3854316084e-01 * x4 + -3.6053953676e-01 * x5);
    h29 = tanh(-3.0303088569e-01 + -3.5262241408e-01 * x0 + 7.4969047547e-02 * x1 + -1.1465128243e-01 * x2 + -8.9715876115e-02 * x3 + 1.8316535207e-01 * x4 + 1.2951774394e-01 * x5);
    h30 = tanh(4.7155066149e-01 + -2.2184260020e-01 * x0 + -1.3864398957e-01 * x1 + 4.6809582416e-01 * x2 + 3.7100004181e-01 * x3 + 1.7586515844e-01 * x4 + -1.3388798999e-01 * x5);
    h31 = tanh(2.5835405136e-01 + 2.3392738178e-02 * x0 + 1.2308369456e-01 * x1 + 3.5763988829e-01 * x2 + 1.4875689225e-01 * x3 + -1.2910352232e-02 * x4 + -4.0242217910e-01 * x5);
    k0 = tanh(-1.1166001875e-01 + 6.5442504696e-02 * h0 + 7.1594449529e-02 * h1 + -9.5305807307e-02 * h2 + -1.3683006580e-01 * h3 + 9.8983071261e-03 * h4 + 3.9867967480e-02 * h5 + 2.8866768514e-03 * h6 + 3.4005928208e-02 * h7 + 3.7025398352e-02 * h8 + -8.9228932389e-02 * h9 + -8.4225834477e-03 * h10 + 9.1690133959e-03 * h11 + -9.3297762185e-02 * h12 + 1.5541319510e-02 * h13 + -7.2324696720e-02 * h14 + -8.9035734146e-02 * h15 + -4.6054877170e-02 * h16 + -1.9011150791e-01 * h17 + -2.9495220323e-02 * h18 + -1.3903384570e-01 * h19 + 2.9280611168e-01 * h20 + 9.5467595782e-03 * h21 + 1.6831752144e-01 * h22 + -1.6066383177e-01 * h23 + -4.9189653647e-02 * h24 + -1.5642318133e-01 * h25 + -1.4991320965e-01 * h26 + 1.5857342036e-01 * h27 + 4.2557857208e-02 * h28 + -9.9321446498e-02 * h29 + 1.1889321389e-01 * h30 + 7.7282994019e-02 * h31);
    k1 = tanh(1.7951985703e-01 + -2.2840053777e-02 * h0 + 2.1897324946e-03 * h1 + 3.1345657405e-02 * h2 + 3.0577065542e-03 * h3 + -5.7223807470e-04 * h4 + -7.8365006314e-02 * h5 + 3.1662818434e-02 * h6 + 4.7855989072e-02 * h7 + -4.6860717918e-02 * h8 + 2.6633379758e-02 * h9 + -5.1540649144e-02 * h10 + -4.7576491120e-02 * h11 + 7.3392923367e-02 * h12 + 2.1612859526e-02 * h13 + 4.5523307804e-02 * h14 + 7.6915026947e-02 * h15 + -3.0834093728e-02 * h16 + 7.4099096223e-02 * h17 + -2.5696233390e-02 * h18 + 1.2698660214e-02 * h19 + -1.2828522935e-01 * h20 + -3.8461340055e-02 * h21 + -5.1907376399e-02 * h22 + 7.3852742100e-02 * h23 + 1.2149639971e-03 * h24 + 4.6664817624e-02 * h25 + 8.2496982957e-02 * h26 + -3.7375769449e-02 * h27 + 4.6422820374e-02 * h28 + -5.5933564400e-02 * h29 + -5.5573746731e-02 * h30 + -1.7320900428e-02 * h31);
    k2 = tanh(9.6267223021e-02 + -3.4392754861e-03 * h0 + -4.2506979331e-02 * h1 + 3.5633635243e-02 * h2 + -1.0511320617e-02 * h3 + 1.8845023768e-02 * h4 + -7.8010279460e-02 * h5 + 5.6017400809e-02 * h6 + -6.7735537941e-02 * h7 + -8.7570933537e-03 * h8 + 2.3371414272e-02 * h9 + 3.3072057778e-04 * h10 + -2.3256928789e-02 * h11 + 5.6026300392e-02 * h12 + -5.5486594226e-02 * h13 + 8.7717347274e-02 * h14 + 9.7952856948e-02 * h15 + -4.0578345996e-02 * h16 + 5.2451913500e-02 * h17 + -2.5350381130e-03 * h18 + -1.0035102160e-02 * h19 + -7.1610325908e-02 * h20 + -1.1147570011e-02 * h21 + 2.3567684342e-02 * h22 + 1.1661322740e-01 * h23 + -4.4653351768e-02 * h24 + 1.0625130378e-01 * h25 + 2.9375133916e-02 * h26 + -4.5177297314e-02 * h27 + -4.6189312507e-02 * h28 + -5.2641450233e-02 * h29 + -7.9901604599e-02 * h30 + 2.8694787003e-02 * h31);
    k3 = tanh(-2.6956889119e-02 + 8.0863031706e-04 * h0 + -9.2574597138e-04 * h1 + -1.2313677705e-03 * h2 + -6.6606410150e-04 * h3 + 3.1348756284e-05 * h4 + -5.0728235396e-03 * h5 + -1.0768203232e-03 * h6 + 3.6955227820e-03 * h7 + 4.0677442368e-04 * h8 + -7.3225325143e-04 * h9 + -1.4982463190e-03 * h10 + -1.0659556739e-03 * h11 + -4.2695480467e-03 * h12 + 1.3671704194e-03 * h13 + -6.9561854437e-04 * h14 + 4.9265987771e-04 * h15 + -1.5509392436e-03 * h16 + 1.1003968952e-03 * h17 + -9.4080993975e-04 * h18 + -1.5436936963e-03 * h19 + -1.9203932678e-03 * h20 + -1.7833870092e-03 * h21 + -5.1216003247e-03 * h22 + -9.8108687305e-05 * h23 + -1.0521196987e-03 * h24 + -7.4690355348e-03 * h25 + 1.9196645619e-03 * h26 + 1.4205808704e-03 * h27 + -3.6189162489e-03 * h28 + -2.3697546401e-03 * h29 + 1.5909561296e-03 * h30 + 1.3676229339e-03 * h31);
    k4 = tanh(-1.2550621349e-01 + -1.1377496175e-01 * h0 + -2.4726765419e-02 * h1 + 9.9824926084e-02 * h2 + -2.2006594997e-02 * h3 + 7.2161506388e-02 * h4 + -1.1487882579e-01 * h5 + 9.6291468820e-02 * h6 + -6.8375762905e-02 * h7 + 1.8066740912e-02 * h8 + -5.9762588901e-02 * h9 + -4.6315198316e-02 * h10 + -5.1074099229e-02 * h11 + 7.7143025604e-02 * h12 + 2.0652165685e-02 * h13 + 1.0239953421e-01 * h14 + 1.2995547197e-01 * h15 + -1.1752009554e-01 * h16 + 9.7759784106e-02 * h17 + -6.1301909269e-02 * h18 + -5.4802898008e-02 * h19 + -8.1815099325e-02 * h20 + -1.5664219084e-02 * h21 + -9.8388198521e-02 * h22 + 1.1177831265e-01 * h23 + -1.0982340075e-01 * h24 + 7.9351509238e-03 * h25 + 7.1870985632e-02 * h26 + -5.8656920210e-02 * h27 + 4.3705797562e-02 * h28 + -8.4918494296e-02 * h29 + -1.3947255332e-01 * h30 + 3.7331144568e-02 * h31);
    k5 = tanh(2.0586145271e-01 + -4.4764612641e-02 * h0 + -5.2289395630e-02 * h1 + 4.2334524808e-02 * h2 + -4.4760725437e-02 * h3 + 1.8333430871e-02 * h4 + -1.1817270353e-01 * h5 + 3.4785880814e-02 * h6 + 7.9868830634e-02 * h7 + -1.0341959733e-01 * h8 + -1.1310356501e-03 * h9 + 6.0539379851e-02 * h10 + -1.2732043836e-01 * h11 + 1.0639285533e-01 * h12 + 8.3592403274e-02 * h13 + 1.0641529211e-01 * h14 + 1.8253299018e-01 * h15 + -6.4323427839e-02 * h16 + 2.0826354721e-01 * h17 + -3.6758840639e-02 * h18 + 5.0230072717e-02 * h19 + -3.1766564907e-01 * h20 + 1.9856666170e-02 * h21 + -1.5813892206e-01 * h22 + 3.3071888757e-02 * h23 + 6.2571072088e-02 * h24 + 1.0680818301e-01 * h25 + 7.3557107311e-02 * h26 + -8.7734494093e-02 * h27 + -2.3623943353e-02 * h28 + -4.4577138517e-02 * h29 + -8.3555517927e-02 * h30 + -1.5860817898e-02 * h31);
    k6 = tanh(3.4019988302e-02 + 3.1291816469e-02 * h0 + 5.8019965754e-02 * h1 + -4.6238121005e-02 * h2 + 1.8843086278e-02 * h3 + -5.5296716542e-03 * h4 + -6.8543392486e-03 * h5 + -2.2857098143e-02 * h6 + -2.0814358521e-03 * h7 + 4.0905380965e-02 * h8 + -6.5014180447e-04 * h9 + 5.8071392681e-02 * h10 + 4.3388143292e-02 * h11 + -6.3804893910e-02 * h12 + 6.4893273769e-02 * h13 + -5.3474104544e-02 * h14 + -4.1125886436e-02 * h15 + 6.9177107041e-02 * h16 + -4.8427995293e-02 * h17 + 2.9652928573e-02 * h18 + 3.3457969542e-02 * h19 + 8.9891075937e-02 * h20 + -3.2313585165e-02 * h21 + -1.2379857444e-03 * h22 + -1.0119387711e-01 * h23 + -5.0947918577e-03 * h24 + -7.7244114313e-02 * h25 + -4.4687609201e-02 * h26 + 5.4661343081e-02 * h27 + -5.3692732437e-02 * h28 + 6.9877999939e-02 * h29 + 9.1083182092e-02 * h30 + 4.3546604169e-03 * h31);
    k7 = tanh(-1.0737706037e-01 + 4.7417677492e-03 * h0 + 3.9470231575e-03 * h1 + -4.0275749791e-03 * h2 + -1.5184950898e-03 * h3 + 1.0781310672e-03 * h4 + 9.0325157812e-03 * h5 + -6.4940757950e-03 * h6 + 1.3578989915e-02 * h7 + 2.3098170911e-03 * h8 + -4.5680297394e-03 * h9 + 1.1171859607e-03 * h10 + 4.2068545912e-03 * h11 + -2.1333489726e-02 * h12 + 4.2585879865e-03 * h13 + -4.9071255713e-03 * h14 + -8.8563647050e-04 * h15 + -3.9403314462e-04 * h16 + 1.1557719981e-02 * h17 + -5.1100144740e-03 * h18 + -8.0717077922e-03 * h19 + 6.5243294275e-04 * h20 + -6.7364759854e-03 * h21 + -8.8767892510e-03 * h22 + -6.8751255494e-03 * h23 + -1.7529203798e-03 * h24 + -6.6216380925e-02 * h25 + -1.3081909588e-02 * h26 + 1.0048907472e-02 * h27 + -1.8367319908e-02 * h28 + -4.0493594616e-03 * h29 + 2.4036232033e-02 * h30 + 8.9377854797e-03 * h31);
    k8 = tanh(-6.3340543359e-02 + 1.3938260782e-01 * h0 + 2.5042530084e-01 * h1 + 3.7181838946e-02 * h2 + 1.1174130908e+00 * h3 + -2.3336331841e-01 * h4 + 2.1656307719e-01 * h5 + -1.3869490861e-02 * h6 + -4.5581510639e-02 * h7 + -9.4716177785e-02 * h8 + 3.6841178470e-01 * h9 + -4.1444998415e-02 * h10 + 9.4303890456e-02 * h11 + -1.0866079998e-01 * h12 + -8.3953707843e-02 * h13 + -3.2520459748e-01 * h14 + -4.2211158114e-01 * h15 + 1.1818782722e-01 * h16 + -2.7646473534e-01 * h17 + -5.8299198893e-02 * h18 + 4.7513119677e-01 * h19 + 3.5751141714e-01 * h20 + 6.3370449500e-01 * h21 + 2.1196368987e-01 * h22 + -2.0671636436e-01 * h23 + 2.5767191549e-01 * h24 + 6.0787289066e-03 * h25 + -2.9320876822e-01 * h26 + -9.4388775860e-02 * h27 + 6.2139291740e-02 * h28 + 3.4201633571e-01 * h29 + 3.6254518695e-02 * h30 + -3.4967885591e-01 * h31);
    k9 = tanh(6.4221570824e-02 + 1.2040489532e-01 * h0 + 3.4392181575e-02 * h1 + -1.0135495657e-01 * h2 + -2.0176920561e-02 * h3 + -5.8540624928e-03 * h4 + 1.8401407431e-01 * h5 + 9.6320002659e-03 * h6 + 5.8779293676e-02 * h7 + 4.8633466374e-02 * h8 + 5.0215001084e-02 * h9 + 1.0349861950e-02 * h10 + -6.2903343169e-02 * h11 + -1.1244662133e-01 * h12 + 7.5506672876e-02 * h13 + -1.6183754385e-01 * h14 + -1.5152124170e-01 * h15 + 1.1561717089e-01 * h16 + -1.8399024770e-01 * h17 + 1.4947338426e-01 * h18 + 8.9513024129e-02 * h19 + 1.7630270371e-01 * h20 + -1.5272500011e-02 * h21 + 1.2190946840e-01 * h22 + -1.6086238976e-01 * h23 + -6.1376456214e-02 * h24 + -1.4080474906e-02 * h25 + -1.0896996778e-01 * h26 + 4.8026724163e-02 * h27 + -1.3085248221e-04 * h28 + 1.0839496949e-01 * h29 + 2.9671938150e-02 * h30 + -1.6413117305e-02 * h31);
    k10 = tanh(6.9902365636e-02 + -2.6902739757e-02 * h0 + -1.6687621333e-02 * h1 + 4.8593678039e-02 * h2 + -1.6095473047e-02 * h3 + 2.6368195913e-02 * h4 + -2.0462410133e-02 * h5 + 3.7696274547e-02 * h6 + 2.1560044068e-03 * h7 + -1.2708674688e-02 * h8 + 1.6669557594e-02 * h9 + -2.3157225550e-02 * h10 + -3.5587438363e-02 * h11 + 7.1266182341e-02 * h12 + -5.2066557251e-03 * h13 + 8.1388555344e-02 * h14 + 7.7010764854e-02 * h15 + -1.5813996996e-02 * h16 + 3.6039615158e-02 * h17 + -1.6810230485e-02 * h18 + -7.7174420950e-03 * h19 + -7.9798264835e-02 * h20 + -2.5824307232e-02 * h21 + -2.9241129691e-02 * h22 + 1.0900228909e-01 * h23 + -3.2066862215e-02 * h24 + 8.4182895790e-02 * h25 + 2.7373428118e-02 * h26 + -4.1241153650e-02 * h27 + 3.5433280223e-02 * h28 + -4.4540810193e-02 * h29 + -8.3658075761e-02 * h30 + 2.4072163890e-02 * h31);
    k11 = tanh(2.7903453566e-02 + 9.2412634203e-02 * h0 + 1.3046103838e-01 * h1 + -1.5433564491e-01 * h2 + -1.4099644308e-01 * h3 + 1.5050120268e-02 * h4 + 8.8042631964e-02 * h5 + -6.8112258923e-02 * h6 + 3.4660235430e-02 * h7 + 8.4075645172e-02 * h8 + -1.8569828873e-01 * h9 + 5.3167424489e-02 * h10 + -7.9450350080e-02 * h11 + -1.6186101230e-01 * h12 + -1.9578364460e-04 * h13 + -9.0400571926e-03 * h14 + -2.9810406444e-02 * h15 + -1.3632161619e-01 * h16 + -2.2980985508e-01 * h17 + 6.1058339347e-02 * h18 + -8.3575912463e-02 * h19 + 3.5442460996e-01 * h20 + 2.4597501251e-02 * h21 + 8.8067628101e-02 * h22 + -8.7864899788e-02 * h23 + -4.5368970703e-02 * h24 + -8.2228719705e-03 * h25 + -9.5154288546e-02 * h26 + 2.4110270711e-01 * h27 + 3.5832943245e-03 * h28 + -7.7056468028e-02 * h29 + 1.8034271715e-01 * h30 + -6.1486636413e-02 * h31);
    k12 = tanh(-1.8214003787e-01 + -2.1694738565e-03 * h0 + 9.3847726702e-02 * h1 + -1.4035871423e-01 * h2 + -1.9171904344e-03 * h3 + -2.1467556950e-02 * h4 + 1.2898638998e-01 * h5 + -8.9725585206e-02 * h6 + 1.3630040562e-01 * h7 + 4.5817550480e-03 * h8 + -4.3136106449e-02 * h9 + 6.3542920191e-02 * h10 + 7.9137495570e-02 * h11 + -1.3191214126e-01 * h12 + 4.9674314764e-02 * h13 + -1.0302866063e-01 * h14 + -1.3495508690e-01 * h15 + 2.8012113709e-02 * h16 + -2.4024831478e-01 * h17 + -4.6304311816e-02 * h18 + 7.2036087665e-02 * h19 + 2.4860614552e-01 * h20 + 1.1471110005e-01 * h21 + 1.5999495468e-01 * h22 + -1.3340348912e-01 * h23 + -2.0873097622e-02 * h24 + -3.9115198142e-02 * h25 + -5.6129100559e-02 * h26 + 4.6023175204e-02 * h27 + 1.0878980756e-02 * h28 + -9.4772863008e-02 * h29 + 1.3360880898e-01 * h30 + -1.6889881352e-02 * h31);
    k13 = tanh(-2.0784480756e-01 + -2.7688564858e-02 * h0 + 8.8391481672e-02 * h1 + -6.3243950409e-02 * h2 + 4.4576527951e-02 * h3 + -4.1162298877e-02 * h4 + -1.2947171742e-02 * h5 + -4.4497203591e-02 * h6 + 6.2132429682e-02 * h7 + 3.5995626098e-02 * h8 + 8.0186277164e-03 * h9 + 3.2106477839e-03 * h10 + 1.0623928431e-01 * h11 + 1.5311391328e-02 * h12 + 1.7392811792e-02 * h13 + -1.4997556836e-01 * h14 + -6.2169566707e-02 * h15 + 5.4305615446e-02 * h16 + -2.3760436605e-02 * h17 + 5.7348608258e-03 * h18 + 3.2537080048e-02 * h19 + 1.3405750307e-01 * h20 + 8.3408375229e-02 * h21 + -4.8555752755e-02 * h22 + -1.8120551055e-01 * h23 + -4.4181768062e-02 * h24 + -1.9970971635e-01 * h25 + -1.1932318002e-01 * h26 + 6.7415585145e-02 * h27 + 6.5845498497e-02 * h28 + -5.9912016130e-02 * h29 + 7.1116960262e-02 * h30 + 2.0445894997e-02 * h31);
    k14 = tanh(-1.2857007336e-01 + 1.2602952085e-01 * h0 + 1.6682716071e-01 * h1 + 1.2671907034e-01 * h2 + 6.1340106687e-01 * h3 + -5.2679947433e-02 * h4 + 1.4225723805e-01 * h5 + 8.4334608138e-02 * h6 + -3.7788998965e-01 * h7 + -2.4397572308e-01 * h8 + 1.3402773546e-01 * h9 + -1.8921408621e-01 * h10 + -8.4367924467e-02 * h11 + 3.7487545176e-01 * h12 + -2.0298459158e-01 * h13 + -1.4336819171e-01 * h14 + 2.4322475262e-02 * h15 + 1.3150284116e-01 * h16 + 3.0194440448e-01 * h17 + 1.7658817515e-01 * h18 + 1.4180297022e-01 * h19 + -4.1538187736e-01 * h20 + 6.9159586352e-02 * h21 + 2.9136546429e-02 * h22 + 5.4763276785e-01 * h23 + 1.5237411597e-01 * h24 + 3.9846829114e-01 * h25 + -2.2575272231e-01 * h26 + -4.4216527433e-01 * h27 + 3.4888662567e-01 * h28 + 2.9637161667e-01 * h29 + -5.8229437120e-01 * h30 + -3.9308712872e-01 * h31);
    k15 = tanh(-1.5880685581e-01 + -1.3190556471e-01 * h0 + 9.4777218890e-02 * h1 + -2.0324270094e-01 * h2 + 4.3177759193e-01 * h3 + -2.3964344114e-02 * h4 + -4.0953529921e-02 * h5 + -1.6973456126e-01 * h6 + 6.4362649371e-02 * h7 + 8.9771046359e-02 * h8 + -9.2121961266e-02 * h9 + 9.5528737035e-02 * h10 + 1.1165680980e-01 * h11 + -2.4781399490e-01 * h12 + 1.8219619784e-01 * h13 + -2.8810524928e-01 * h14 + -7.4396784732e-02 * h15 + 4.6968694485e-02 * h16 + -2.3428968093e-01 * h17 + 1.5074358017e-01 * h18 + 6.5029014210e-02 * h19 + 2.6401838606e-01 * h20 + 2.0148631420e-01 * h21 + -7.1496215863e-02 * h22 + -2.7421595510e-01 * h23 + -2.0498862787e-01 * h24 + -2.8466064664e-01 * h25 + -6.0500836932e-02 * h26 + -1.9110144927e-01 * h27 + -1.3587763161e-01 * h28 + 1.5162143914e-01 * h29 + -1.5219622266e-02 * h30 + -8.8229721317e-02 * h31);
    k16 = tanh(-1.3196447912e-01 + 1.1783893894e-02 * h0 + -8.5020448982e-02 * h1 + -1.4690102087e-02 * h2 + -2.2167796625e-01 * h3 + 8.8346460215e-02 * h4 + -2.2470703831e-02 * h5 + 4.6283767658e-02 * h6 + -3.8864882397e-02 * h7 + -9.5627869955e-02 * h8 + -1.3001791185e-01 * h9 + -4.4282874004e-03 * h10 + -5.5933433494e-02 * h11 + -3.6123669156e-02 * h12 + -9.9058620165e-02 * h13 + 1.5056187529e-01 * h14 + 1.3961895347e-01 * h15 + -1.6024746011e-01 * h16 + 1.4224747871e-01 * h17 + -2.1719458961e-01 * h18 + -1.3796886356e-01 * h19 + -1.1159211290e-01 * h20 + -8.4883067577e-02 * h21 + -1.2752629238e-01 * h22 + 2.1047289823e-01 * h23 + -7.9067655397e-04 * h24 + 1.7761203703e-01 * h25 + 5.2174682301e-02 * h26 + 1.1860475697e-02 * h27 + 8.0147801628e-02 * h28 + -8.6639670694e-02 * h29 + -2.3406598141e-02 * h30 + -3.1495575829e-02 * h31);
    k17 = tanh(1.9737656353e-02 + -1.2648049624e-02 * h0 + -3.0747320442e-02 * h1 + 6.8778384386e-02 * h2 + -1.2984656973e-02 * h3 + 3.7822740320e-02 * h4 + -1.7420967848e-01 * h5 + 7.3317633841e-02 * h6 + 2.5116353076e-02 * h7 + -5.0737083762e-02 * h8 + 6.4642441468e-02 * h9 + 1.9918040605e-02 * h10 + -8.8439220325e-02 * h11 + 1.4583046580e-01 * h12 + -3.3498748073e-03 * h13 + 1.1302203477e-01 * h14 + 1.4675372935e-01 * h15 + -2.9483493449e-03 * h16 + 1.2341653443e-01 * h17 + 2.0241491382e-02 * h18 + 5.2149417117e-02 * h19 + -9.6831964595e-02 * h20 + -2.3589229484e-02 * h21 + -1.3145686094e-01 * h22 + 1.0757444598e-01 * h23 + -5.1506802709e-02 * h24 + 7.6955757086e-02 * h25 + 1.1383696842e-01 * h26 + -6.8805034992e-02 * h27 + -1.4871209625e-03 * h28 + -8.8622242489e-02 * h29 + -1.3455604712e-01 * h30 + -7.9701897165e-02 * h31);
    k18 = tanh(-5.1671755534e-02 + 1.1190453586e-01 * h0 + 1.5848327697e-01 * h1 + -1.4019130237e-01 * h2 + -2.8152173393e-01 * h3 + -9.1080200844e-02 * h4 + -2.9477629572e-02 * h5 + 3.7071745417e-02 * h6 + 1.5181544654e-01 * h7 + 1.5855995259e-01 * h8 + -1.2445181095e-01 * h9 + 1.0813230074e-01 * h10 + -1.4171686812e-01 * h11 + -1.9124688130e-01 * h12 + -8.1399213875e-03 * h13 + -1.3967188635e-01 * h14 + -6.4765340550e-02 * h15 + -8.6259613020e-02 * h16 + -4.3937363106e-01 * h17 + -1.5654311257e-02 * h18 + -3.1028576344e-01 * h19 + 3.9766331238e-01 * h20 + 6.5485337431e-02 * h21 + 1.8964382503e-02 * h22 + -3.6686227738e-01 * h23 + -5.6302601941e-03 * h24 + -1.3268417752e-01 * h25 + -4.6011971872e-02 * h26 + 2.1047305568e-01 * h27 + -7.3540252130e-02 * h28 + -9.2870522221e-03 * h29 + 2.5848995192e-01 * h30 + 1.5455780322e-01 * h31);
    k19 = tanh(9.5574096864e-02 + 3.9335505024e-02 * h0 + 8.0786776737e-02 * h1 + 6.4682073380e-03 * h2 + -8.8209199887e-02 * h3 + -1.7249201480e-02 * h4 + 1.0399144964e-01 * h5 + -6.4669266251e-02 * h6 + 1.5131298857e-01 * h7 + -3.4452081945e-03 * h8 + -3.5247028609e-02 * h9 + 4.1912050791e-02 * h10 + 1.3400583454e-02 * h11 + -4.5154597283e-03 * h12 + 8.6555740013e-02 * h13 + -2.5824935753e-02 * h14 + -1.4688013513e-03 * h15 + -4.4928156255e-03 * h16 + -1.0937670798e-01 * h17 + -3.5740406615e-02 * h18 + -8.1580964754e-02 * h19 + 1.2209461935e-01 * h20 + 2.9742053106e-02 * h21 + 5.1103015951e-02 * h22 + -1.4919155037e-01 * h23 + -3.4158854925e-02 * h24 + -1.4336219507e-01 * h25 + -2.7865764532e-02 * h26 + 1.5641183658e-01 * h27 + -6.7888897236e-02 * h28 + -7.3594957179e-02 * h29 + 1.7348719135e-01 * h30 + 4.2974352492e-02 * h31);
    k20 = tanh(-1.2670744957e-01 + -5.9642761717e-02 * h0 + -1.1336213238e-01 * h1 + 4.0800857492e-02 * h2 + 3.3788076566e-02 * h3 + -4.8532992892e-04 * h4 + -1.5841876190e-01 * h5 + -3.0110059954e-02 * h6 + 2.9454586420e-02 * h7 + -6.4287103521e-02 * h8 + 3.9630880929e-02 * h9 + -2.8756700614e-02 * h10 + 5.0625626177e-03 * h11 + 8.5057144219e-04 * h12 + 1.3472642374e-02 * h13 + 2.1870152670e-02 * h14 + 2.5000230100e-02 * h15 + 8.7879932772e-02 * h16 + 7.9069124357e-02 * h17 + -3.2507195753e-04 * h18 + 5.1676861731e-02 * h19 + -1.5587546469e-01 * h20 + 7.5252195357e-02 * h21 + 3.0869969174e-02 * h22 + 1.2514643549e-01 * h23 + 3.9750917180e-03 * h24 + 1.2807610796e-01 * h25 + 2.1174879730e-02 * h26 + -1.3075881221e-01 * h27 + 1.0007487934e-01 * h28 + -3.4845785687e-03 * h29 + -6.9882165434e-02 * h30 + 3.6292758945e-03 * h31);
    k21 = tanh(-1.5349303686e-01 + -2.5644547959e-01 * h0 + -2.2412470609e-01 * h1 + 2.1757243522e-01 * h2 + 6.0063619334e-01 * h3 + 8.7429191898e-02 * h4 + -1.5874980046e-01 * h5 + -2.5001490542e-02 * h6 + -1.6869547319e-01 * h7 + -1.1505379714e-01 * h8 + 1.2690542869e-01 * h9 + -1.2859253628e-01 * h10 + 8.1750815109e-02 * h11 + 2.4262412978e-01 * h12 + -4.1446168553e-02 * h13 + -2.7890646180e-02 * h14 + -2.3343138840e-01 * h15 + 2.6558087498e-01 * h16 + 3.1467319291e-01 * h17 + 1.0653320675e-01 * h18 + 4.2711394692e-01 * h19 + -4.9251458247e-01 * h20 + -7.7789334030e-02 * h21 + 2.5988734214e-02 * h22 + 1.6963240628e-01 * h23 + 2.2101292060e-01 * h24 + 2.5552697219e-01 * h25 + 1.5786507293e-01 * h26 + -5.3714046497e-01 * h27 + 9.9439176308e-04 * h28 + 1.6566018685e-01 * h29 + -4.0035670442e-01 * h30 + -1.0239251739e-01 * h31);
    k22 = tanh(-8.5843073934e-02 + -1.3542732173e-02 * h0 + -5.5830291477e-02 * h1 + 1.0191305595e-01 * h2 + -1.4401782535e-01 * h3 + 6.8018693815e-02 * h4 + -1.7246191725e-01 * h5 + 5.2708307647e-02 * h6 + 1.6263685373e-03 * h7 + 3.8853178507e-02 * h8 + -4.4662203268e-02 * h9 + -7.3698128738e-02 * h10 + 5.8978061314e-02 * h11 + 1.6194449773e-01 * h12 + 4.0324562224e-02 * h13 + 1.4583207356e-01 * h14 + 1.4855849916e-01 * h15 + -4.7047011755e-02 * h16 + 5.9117008914e-02 * h17 + 2.7317543221e-02 * h18 + 2.8986316218e-02 * h19 + -6.9806964149e-02 * h20 + -5.7227057569e-02 * h21 + -1.7965856469e-01 * h22 + 5.5199757326e-02 * h23 + -1.0462873070e-01 * h24 + 2.0119411500e-01 * h25 + 1.0471126312e-01 * h26 + -3.4929558547e-02 * h27 + -3.7901862641e-02 * h28 + -1.2445832140e-01 * h29 + -6.2326187744e-02 * h30 + -6.9869320443e-03 * h31);
    k23 = tanh(-8.9673331262e-02 + -3.9307618525e-01 * h0 + 5.9094216925e-01 * h1 + 2.4080673841e-01 * h2 + -1.4762014206e-01 * h3 + 4.4818766093e-01 * h4 + 4.4813643558e-02 * h5 + 3.5319045746e-01 * h6 + -2.2106842279e-01 * h7 + -4.8815298018e-01 * h8 + -3.8969752515e-01 * h9 + -4.1715689979e-02 * h10 + -2.1752621090e-01 * h11 + 3.7257297029e-01 * h12 + -1.2337761664e-01 * h13 + 1.1998591716e-01 * h14 + 1.8556175682e-01 * h15 + 1.3013996935e-02 * h16 + -4.3608373502e-02 * h17 + 5.5033464987e-01 * h18 + -2.9338506108e-01 * h19 + -7.7513071572e-03 * h20 + 8.5783436545e-02 * h21 + 1.3287044426e-01 * h22 + -6.8209722960e-01 * h23 + -1.6473555887e-01 * h24 + 3.7970303248e-01 * h25 + 9.7811297669e-03 * h26 + -1.2416234086e-01 * h27 + 1.1488019798e-02 * h28 + 1.6098522466e-01 * h29 + -2.9417830398e-02 * h30 + 1.0717838303e-01 * h31);
    k24 = tanh(1.5051334279e-01 + -1.3079045057e-01 * h0 + -1.9095750009e-01 * h1 + 1.8585892686e-01 * h2 + -1.4825216432e-01 * h3 + 4.9262468019e-02 * h4 + -5.5483364979e-02 * h5 + 5.7480908159e-02 * h6 + -6.4506949553e-02 * h7 + -7.8273573189e-02 * h8 + -7.3472943725e-02 * h9 + -8.8749797403e-02 * h10 + -8.1499081803e-02 * h11 + 1.5804838017e-01 * h12 + -1.0881726086e-01 * h13 + 1.5444776326e-01 * h14 + 1.5670144101e-01 * h15 + -3.3036598208e-02 * h16 + 2.8521252055e-01 * h17 + -9.8222079045e-02 * h18 + -8.7905120593e-02 * h19 + -2.5375293967e-01 * h20 + -1.1106995354e-01 * h21 + 3.8757038813e-02 * h22 + 2.2299039689e-01 * h23 + -1.0785461955e-01 * h24 + 5.8065122874e-02 * h25 + 7.8851556169e-02 * h26 + -5.8628106795e-03 * h27 + 1.9021683047e-02 * h28 + -2.7485560630e-02 * h29 + -2.1203250605e-01 * h30 + -8.1633010179e-03 * h31);
    k25 = tanh(1.2991285029e-02 + -4.0780454495e-04 * h0 + 7.6953973021e-04 * h1 + 3.0413837163e-04 * h2 + 3.3411340233e-04 * h3 + 1.0863189188e-04 * h4 + 2.4087481891e-03 * h5 + 6.6085123573e-04 * h6 + -1.8466968930e-03 * h7 + -5.8334044792e-04 * h8 + 2.2999058102e-04 * h9 + 2.6158404350e-04 * h10 + 4.4134666211e-04 * h11 + 1.7861696240e-03 * h12 + -5.6469851400e-04 * h13 + 2.3667619123e-04 * h14 + -2.8338397259e-04 * h15 + 9.2668476478e-04 * h16 + -5.1963876615e-04 * h17 + 5.0030741025e-04 * h18 + 7.4095088510e-04 * h19 + 8.2790725890e-04 * h20 + 1.3620960558e-03 * h21 + 2.3554413900e-03 * h22 + 9.6453401721e-05 * h23 + 1.6339292194e-04 * h24 + 2.9607311653e-03 * h25 + -1.0723216821e-03 * h26 + -6.8822238236e-04 * h27 + 1.5542812719e-03 * h28 + 1.0670061693e-03 * h29 + -1.0902050972e-03 * h30 + -8.2585942868e-04 * h31);
    k26 = tanh(9.4239144408e-02 + -4.3753909338e-03 * h0 + 8.4805545522e-02 * h1 + -8.0773947664e-02 * h2 + -8.0914457256e-01 * h3 + 9.6157008067e-02 * h4 + 5.5022973374e-02 * h5 + 2.6803444350e-01 * h6 + 2.0289390838e-02 * h7 + -2.6009550675e-01 * h8 + -2.3723608836e-01 * h9 + 1.2355389726e-02 * h10 + -7.2035478327e-02 * h11 + 4.0191233531e-02 * h12 + -1.2323347145e-01 * h13 + 1.6220747358e-01 * h14 + 1.7058311800e-01 * h15 + -2.8125086347e-02 * h16 + 1.5103028145e-01 * h17 + -1.6366440063e-01 * h18 + -2.4005406567e-01 * h19 + -3.5444765175e-01 * h20 + -2.2367097385e-01 * h21 + -1.3200942070e-01 * h22 + 3.0987172062e-01 * h23 + 7.3876432451e-02 * h24 + 1.5544474827e-01 * h25 + 1.6107937245e-01 * h26 + 9.8161712551e-02 * h27 + 1.2434009939e-01 * h28 + -1.2907507009e-02 * h29 + -1.5606992902e-01 * h30 + 8.7880527101e-02 * h31);
    k27 = tanh(-1.1594953521e-01 + 4.4335490628e-03 * h0 + -4.4391879148e-03 * h1 + -3.7075401549e-03 * h2 + -3.6848500048e-03 * h3 + 8.7560590407e-05 * h4 + -4.9068718948e-03 * h5 + -6.0866056294e-03 * h6 + 1.8034456560e-02 * h7 + 5.3444556107e-03 * h8 + -3.4246504453e-03 * h9 + -1.5986381902e-03 * h10 + -3.6022005278e-03 * h11 + -2.2674817066e-02 * h12 + 5.5411830277e-03 * h13 + -3.0042685167e-03 * h14 + 1.9575040122e-03 * h15 + -7.5077032950e-03 * h16 + 7.0377242856e-03 * h17 + -4.5638927957e-03 * h18 + -7.8731690010e-03 * h19 + -5.8397325540e-03 * h20 + -1.1584939179e-02 * h21 + -1.4531858934e-02 * h22 + -2.5055307970e-03 * h23 + -2.9054803788e-03 * h24 + -3.7628072393e-02 * h25 + 4.6746856451e-03 * h26 + 8.6906959066e-03 * h27 + -1.5390345211e-02 * h28 + -8.5603456367e-03 * h29 + 1.4635686636e-02 * h30 + 9.5854915593e-03 * h31);
    k28 = tanh(-1.0881769354e-01 + 4.2959230938e-02 * h0 + 9.1535456711e-02 * h1 + -7.1051902272e-02 * h2 + -3.0450949015e-02 * h3 + 6.5952396141e-03 * h4 + 1.4459640432e-01 * h5 + -1.7133119274e-02 * h6 + -2.9528445362e-02 * h7 + -9.2008963327e-03 * h8 + -3.1081245002e-02 * h9 + 6.2038636006e-02 * h10 + -4.4750080366e-02 * h11 + -7.6045410218e-02 * h12 + 3.1255438287e-02 * h13 + -4.3413193189e-02 * h14 + -9.1927099293e-02 * h15 + -6.0532391829e-03 * h16 + -1.0882792935e-01 * h17 + -6.7331350812e-03 * h18 + -3.6345418077e-02 * h19 + 1.0906679363e-01 * h20 + 1.9496290630e-02 * h21 + 7.2636483791e-02 * h22 + -1.0518967476e-02 * h23 + -3.1933378158e-02 * h24 + -7.1461463027e-02 * h25 + -1.0051368499e-01 * h26 + 1.0180294907e-01 * h27 + 2.1019707384e-02 * h28 + 6.0417854423e-02 * h29 + 1.6282208090e-01 * h30 + 4.5587825120e-02 * h31);
    k29 = tanh(-9.9501270951e-02 + 8.2051969496e-03 * h0 + 4.4119366704e-02 * h1 + -1.2366627193e-01 * h2 + 2.8848716210e-03 * h3 + 5.3121273341e-03 * h4 + 1.3598404883e-01 * h5 + -7.5017530830e-02 * h6 + 7.9679978244e-02 * h7 + 9.1463467309e-03 * h8 + -2.8602152183e-02 * h9 + 6.9588101148e-02 * h10 + 7.2305732835e-02 * h11 + -1.2103831091e-01 * h12 + -5.0925986512e-02 * h13 + -1.2831508794e-01 * h14 + -1.3121905897e-01 * h15 + -2.0363508244e-02 * h16 + -9.2469491903e-02 * h17 + 2.9014246145e-02 * h18 + 3.0529824133e-02 * h19 + 1.6511499653e-01 * h20 + 6.6270015773e-02 * h21 + 2.1716430028e-02 * h22 + -1.3570555555e-01 * h23 + 5.9390990891e-02 * h24 + -1.3741846438e-01 * h25 + -9.6166195090e-02 * h26 + 6.6081903182e-02 * h27 + 9.7036086018e-02 * h28 + -3.3124218060e-02 * h29 + 1.1613817242e-01 * h30 + 3.1828530423e-02 * h31);
    k30 = tanh(4.5405416574e-02 + 2.7927794642e-02 * h0 + -2.8126399455e-02 * h1 + 9.3033543405e-02 * h2 + -1.7859043869e-01 * h3 + 4.1174318202e-03 * h4 + -4.8514558796e-02 * h5 + 8.0066375873e-02 * h6 + 3.7223514876e-02 * h7 + -3.6596411472e-02 * h8 + -3.4559164702e-02 * h9 + -6.9776360136e-02 * h10 + -4.4753400212e-02 * h11 + 9.6313661375e-02 * h12 + -1.1140973233e-02 * h13 + 1.4814484202e-01 * h14 + 1.0774820354e-01 * h15 + -4.7653608164e-02 * h16 + 1.4589985150e-01 * h17 + -5.3919840446e-02 * h18 + 1.6168153213e-02 * h19 + -8.8908940017e-02 * h20 + -1.2756691791e-01 * h21 + -4.4264544192e-02 * h22 + 1.7736728382e-01 * h23 + 1.0781343094e-03 * h24 + 1.9922319540e-01 * h25 + 4.6294788856e-02 * h26 + -3.0050706006e-02 * h27 + 1.4442799270e-02 * h28 + -7.7356359270e-02 * h29 + -9.3205112003e-02 * h30 + 1.1855886973e-01 * h31);
    k31 = tanh(-4.6754325527e-02 + -9.0823353806e-02 * h0 + -6.8653032336e-02 * h1 + 7.9097395222e-02 * h2 + 5.0456285907e-02 * h3 + -2.0471438790e-02 * h4 + -1.4823934748e-01 * h5 + 5.6468700892e-02 * h6 + -9.0829404032e-02 * h7 + 5.7019188780e-03 * h8 + 5.5505458098e-02 * h9 + -6.4933206075e-03 * h10 + 2.5674261735e-02 * h11 + -6.7807705686e-03 * h12 + -9.7233113587e-02 * h13 + 8.2652497519e-02 * h14 + 4.4587765486e-02 * h15 + -4.5728892654e-02 * h16 + 1.7293674366e-01 * h17 + -6.1928919891e-02 * h18 + 5.8816184026e-02 * h19 + -1.7444859898e-01 * h20 + 9.2428285012e-02 * h21 + -1.2036058996e-01 * h22 + 1.0261144217e-01 * h23 + 1.6095013684e-02 * h24 + 4.5109165804e-02 * h25 + 6.5161343947e-02 * h26 + -1.1402924908e-01 * h27 + 2.5453131843e-02 * h28 + -6.2211145066e-02 * h29 + -1.0920914724e-01 * h30 + -5.6602725366e-02 * h31);
    acc = -4.4562919832e-02 + 5.1663320498e-01 * k0 + -5.5376828037e-02 * k1 + -9.4999648649e-02 * k2 + 4.5772575403e-05 * k3 + -1.1087579653e-01 * k4 + -1.2932168100e-01 * k5 + 3.7249433951e-02 * k6 + 3.0785070840e-03 * k7 + 2.5383201802e-01 * k8 + 2.3966319266e-01 * k9 + -6.8402551907e-02 * k10 + 3.3601837861e-01 * k11 + 1.6141757092e-01 * k12 + 1.5344210132e-01 * k13 + -1.5173268532e-01 * k14 + 5.8888608103e-01 * k15 + -1.8740686529e-01 * k16 + -1.6069223568e-01 * k17 + 5.2399023607e-01 * k18 + 6.0357219891e-02 * k19 + -4.2786204246e-02 * k20 + -2.3325329721e-01 * k21 + -2.7631201270e-01 * k22 + -1.7189290911e-01 * k23 + -3.5729941733e-01 * k24 + -4.5086017790e-06 * k25 + -2.7148433078e-01 * k26 + 8.6670986261e-04 * k27 + 7.8475760299e-02 * k28 + 2.2950388015e-01 * k29 + -1.5346099907e-01 * k30 + -1.1955569341e-01 * k31;
    gsum = gsum + 1 * tanh(acc);
    // ensemble member 3
    h0 = tanh(-1.2810205486e-01 + -4.1515521917e-01 * x0 + -3.8582615226e-01 * x1 + -1.4019418644e-01 * x2 + -4.2301163897e-01 * x3 + -2.0255378123e-02 * x4 + -1.6639532032e-01 * x5);
    h1 = tanh(3.1505478010e-02 + 8.8577722046e-02 * x0 + 5.6232989118e-02 * x1 + 8.5730450357e-02 * x2 + 2.6108878647e-01 * x3 + -8.2431746997e-02 * x4 + 3.2175385267e-01 * x5);
    h2 = tanh(1.5497543030e-01 + -4.3240978681e-01 * x0 + -2.5854867004e-01 * x1 + -3.5556376492e-01 * x2 + -2.0560907464e-02 * x3 + -7.3520078587e-02 * x4 + 4.0208877978e-01 * x5);
    h3 = tanh(2.2781846770e-01 + 3.2595085209e-01 * x0 + 2.1440156676e-01 * x1 + 1.4954132281e-01 * x2 + 5.0430415049e-02 * x3 + 3.3324522369e-02 * x4 + -6.9455819084e-01 * x5);
    h4 = tanh(2.7248781881e-02 + -1.6504975432e-01 * x0 + -1.5547630867e-01 * x1 + -1.1095688353e-01 * x2 + 1.0321100039e-01 * x3 + -1.6670220468e-01 * x4 + -3.8302409853e-01 * x5);
    h5 = tanh(9.3214240556e-02 + -4.3251074781e-01 * x0 + 2.7534172348e-01 * x1 + -3.2418005417e-01 * x2 + -3.3355558579e-01 * x3 + -8.2721450625e-01 * x4 + -6.2840750763e-02 * x5);
    h6 = tanh(-1.3542853606e-01 + -1.9315070540e-01 * x0 + -4.1218624325e-01 * x1 + -1.8917954140e-01 * x2 + 2.5415466914e-01 * x3 + 7.7905114891e-03 * x4 + 4.5832687088e-02 * x5);
    h7 = tanh(4.3719877289e-01 + 3.7304178231e-02 * x0 + -1.5931209591e-01 * x1 + 1.6046390606e-01 * x2 + -3.4867727896e-04 * x3 + -6.5564364292e-02 * x4 + -1.5177791453e-01 * x5);
    h8 = tanh(-1.9311014299e-01 + -5.1605248734e-02 * x0 + 4.2002417153e-01 * x1 + 2.6327475321e-01 * x2 + -3.3121433551e-01 * x3 + -1.4301580236e-01 * x4 + 5.1012306143e-01 * x5);
    h9 = tanh(2.0263592712e-01 + 3.5499039648e-01 * x0 + 4.4684213104e-02 * x1 + -3.5671133995e-02 * x2 + 4.3965456358e-01 * x3 + -1.9287111232e-01 * x4 + -2.2146412288e-01 * x5);
    h10 = tanh(6.7307342144e-02 + 5.2172472937e-02 * x0 + 8.8629450916e-02 * x1 + -2.5477028514e-01 * x2 + 2.3155502497e-02 * x3 + -2.5494039746e-01 * x4 + -6.6187268544e-01 * x5);
    h11 = tanh(4.4985533248e-01 + 1.3626966565e-01 * x0 + -2.3503715037e-01 * x1 + 1.8750799837e-02 * x2 + 2.2409355965e-01 * x3 + 1.3424271179e-01 * x4 + 3.2169470843e-01 * x5);
    h12 = tanh(5.1308904842e-01 + -4.0655392300e-02 * x0 + 1.2389523060e-01 * x1 + 1.0520745192e-02 * x2 + 1.6313957435e-01 * x3 + 9.1285245742e-02 * x4 + 7.9565454816e-01 * x5);
    h13 = tanh(-2.2920722966e-01 + 9.2852339014e-02 * x0 + 2.1095181349e-01 * x1 + -3.1615655761e-01 * x2 + -2.6450431044e-01 * x3 + -2.1922589762e-01 * x4 + 1.3791672596e-01 * x5);
    h14 = tanh(3.3138196920e-01 + 4.7237090149e-01 * x0 + -3.5807354929e-01 * x1 + -7.4413408452e-02 * x2 + -4.9488513804e-01 * x3 + -1.6984081150e-01 * x4 + -2.8138611059e-01 * x5);
    h15 = tanh(-1.2465645319e+00 + 1.6340024476e-03 * x0 + 8.4371354334e-02 * x1 + -1.4906697608e+00 * x2 + 1.7042575337e-01 * x3 + -1.3461834269e-01 * x4 + 1.6936377566e-01 * x5);
    h16 = tanh(3.1230587610e-01 + -1.5087338325e-01 * x0 + 1.8686537298e-01 * x1 + -5.6088240988e-02 * x2 + -2.3887282064e-01 * x3 + 7.7419549418e-02 * x4 + 5.7586864472e-02 * x5);
    h17 = tanh(-1.7016216412e-01 + 8.1008662309e-02 * x0 + 3.5509510307e-02 * x1 + 2.1806665038e-01 * x2 + -1.1424260256e-01 * x3 + -7.9709473826e-03 * x4 + -3.4627224843e-02 * x5);
    h18 = tanh(-1.3388980199e-01 + 4.2583310510e-01 * x0 + -2.5454945846e-01 * x1 + 1.5091416302e-01 * x2 + 1.9404758200e-01 * x3 + -9.5111262470e-02 * x4 + -3.8992236911e-01 * x5);
    h19 = tanh(-1.5480063517e-01 + -6.7116303007e-02 * x0 + -2.4832299112e-01 * x1 + 1.5204618178e-01 * x2 + -2.1460149203e-02 * x3 + 4.7064922882e-02 * x4 + 7.8086625681e-01 * x5);
    h20 = tanh(3.9194816991e-01 + 1.5888889256e-01 * x0 + -3.9549289606e-01 * x1 + -1.9346654325e-01 * x2 + -2.1709835097e-01 * x3 + -2.9823317108e-01 * x4 + -1.6353857839e-01 * x5);
    h21 = tanh(1.3222127053e-01 + 1.3581001993e-01 * x0 + 4.0359711444e-02 * x1 + -1.9872077978e-01 * x2 + 2.5382282894e-02 * x3 + 1.0294084031e-01 * x4 + -6.3175327320e-02 * x5);
    h22 = tanh(-2.7232808254e-01 + 1.0828758615e-01 * x0 + -1.8678092668e-01 * x1 + -2.4879012603e-01 * x2 + 1.5261780730e-01 * x3 + 3.1734622563e-01 * x4 + 1.6964221745e-01 * x5);
    h23 = tanh(-2.2233934355e-01 + -1.5118612431e-01 * x0 + 5.4946009930e-02 * x1 + -2.2137120956e-01 * x2 + 2.9983364768e-01 * x3 + 2.5441681721e-02 * x4 + 4.0970705201e-01 * x5);
    h24 = tanh(8.5610946193e-02 + -1.1099605993e-01 * x0 + -5.0387534709e-02 * x1 + 4.8373693323e-02 * x2 + -5.2423775588e-01 * x3 + 1.6629095496e-01 * x4 + 3.8270362215e-01 * x5);
    h25 = tanh(-8.4181816225e-02 + -2.7629055061e-01 * x0 + 4.4381961925e-01 * x1 + -4.2039500331e-02 * x2 + 2.7371755664e-01 * x3 + 1.7002117996e-01 * x4 + -3.4260942271e-01 * x5);
    h26 = tanh(1.0212856922e-01 + 3.2969917880e-01 * x0 + -6.2026906363e-03 * x1 + 1.1747465777e-02 * x2 + -9.6044423640e-02 * x3 + -1.1283732706e-01 * x4 + -5.5727842351e-02 * x5);
    h27 = tanh(2.0706213370e-01 + 1.6560466891e-01 * x0 + 4.9503207010e-02 * x1 + -2.8567762691e-01 * x2 + -3.0205846865e-01 * x3 + 1.2803707059e-01 * x4 + -5.3288997666e-02 * x5);
    h28 = tanh(-2.4537908051e-01 + -1.5259993676e-03 * x0 + -1.1201146260e-01 * x1 + 5.5273074222e-02 * x2 + 1.5368390952e-01 * x3 + -2.1456768304e-01 * x4 + 1.9109626138e-01 * x5);
    h29 = tanh(-3.4026469681e-01 + 4.3547399884e-02 * x0 + 2.6881108607e-01 * x1 + -1.7413400868e-01 * x2 + 3.9188877348e-01 * x3 + 1.0040476271e-01 * x4 + -1.2853060768e-01 * x5);
    h30 = tanh(3.2773784114e-01 + 1.0398782247e+00 * x0 + -1.1130449670e-01 * x1 + 6.4986222399e-01 * x2 + 1.4474368354e-01 * x3 + -1.3359308625e-02 * x4 + 3.0031419192e-01 * x5);
    h31 = tanh(1.8206228126e-01 + 3.5247722944e-03 * x0 + 2.3700293251e-01 * x1 + -4.7712997551e-01 * x2 + -2.6094056964e-01 * x3 + 6.4010008586e-01 * x4 + -4.0942523619e-01 * x5);
    k0 = tanh(8.8831648732e-02 + 1.2376619259e-02 * h0 + -6.6864582798e-03 * h1 + 3.4410583716e-03 * h2 + -4.1290097890e-03 * h3 + 1.0025759098e-02 * h4 + 1.7075113002e-03 * h5 + 9.7365117565e-03 * h6 + -5.4594650014e-03 * h7 + -9.3414485417e-03 * h8 + -4.0165367980e-03 * h9 + 7.2017345133e-03 * h10 + -9.9316228435e-03 * h11 + -2.0207048630e-02 * h12 + 1.1824600554e-03 * h13 + -1.3656424553e-03 * h14 + 1.4767234252e-02 * h15 + -7.5208019854e-03 * h16 + 5.7067738642e-04 * h17 + 6.4056294727e-03 * h18 + -2.9311371163e-03 * h19 + 1.1398533355e-03 * h20 + -2.2211916414e-03 * h21 + 6.3199602034e-03 * h22 + 2.4904197903e-03 * h23 + -4.7948825538e-03 * h24 + 1.1923723736e-03 * h25 + -4.4030823428e-03 * h26 + -3.3459117979e-03 * h27 + 4.2629161840e-03 * h28 + 4.6319816204e-03 * h29 + -1.8406441862e-02 * h30 + -7.2730255441e-04 * h31);
    k1 = tanh(4.5698372736e-02 + 1.7242785678e-01 * h0 + 1.2918852483e-01 * h1 + 5.0623631533e-02 * h2 + 2.3475857144e-02 * h3 + -9.5720421151e-02 * h4 + -9.4255481637e-02 * h5 + 1.0345724644e-01 * h6 + 1.3601554758e-01 * h7 + -1.0243382368e-02 * h8 + -1.0340981949e-01 * h9 + 1.3914084450e-01 * h10 + 9.8497106394e-02 * h11 + 9.0272924193e-02 * h12 + -1.2005157531e-01 * h13 + 8.6377688507e-02 * h14 + -5.2359314673e-02 * h15 + -1.3332037028e-01 * h16 + -6.3597906407e-03 * h17 + -7.2073770748e-02 * h18 + -3.0105483413e-01 * h19 + -3.4794342861e-02 * h20 + -1.0661836134e-01 * h21 + 5.5202013695e-02 * h22 + -7.3838293935e-02 * h23 + -6.7889603177e-02 * h24 + -2.0294153413e-02 * h25 + -3.5881372386e-02 * h26 + -1.0714477909e-01 * h27 + 6.6304445446e-02 * h28 + -1.4891169533e-01 * h29 + 8.5861143475e-02 * h30 + 2.4022029500e-01 * h31);
    k2 = tanh(5.8731458971e-02 + 1.6643795531e-01 * h0 + 6.8170478120e-02 * h1 + 3.1542628570e-03 * h2 + 1.0386564617e-01 * h3 + -8.9971377802e-02 * h4 + 3.2256925795e-02 * h5 + 1.6254663084e-01 * h6 + -2.4865415349e-03 * h7 + -4.3194662837e-02 * h8 + 4.4419029563e-02 * h9 + 1.3937782710e-01 * h10 + 1.3047933287e-01 * h11 + 3.7883059826e-02 * h12 + -1.3464987060e-01 * h13 + 2.9555853806e-02 * h14 + -6.2890632693e-02 * h15 + -1.3340058968e-02 * h16 + -1.7380067892e-03 * h17 + -3.6858501449e-02 * h18 + -1.7530596298e-01 * h19 + -1.6627260508e-02 * h20 + -1.2200643500e-01 * h21 + 1.1456181451e-02 * h22 + 4.2755677005e-02 * h23 + 6.6018069730e-02 * h24 + -6.9574581906e-02 * h25 + -9.3438128450e-02 * h26 + -4.3708794138e-02 * h27 + 5.1239145067e-02 * h28 + 5.7052560703e-02 * h29 + 9.4129526626e-02 * h30 + 4.8429676682e-02 * h31);
    k3 = tanh(1.3720139763e-02 + 2.0544049900e-03 * h0 + -1.0412182380e-03 * h1 + 5.8725966598e-04 * h2 + -6.3689020990e-04 * h3 + 1.5536707500e-03 * h4 + 1.4421341269e-04 * h5 + 1.8350728763e-03 * h6 + -9.0060722271e-04 * h7 + -1.5308066187e-03 * h8 + -6.5211248929e-04 * h9 + 1.1120245328e-03 * h10 + -1.5504039152e-03 * h11 + -2.7426312854e-03 * h12 + 5.7910313171e-05 * h13 + -3.2526656952e-04 * h14 + 2.4654076787e-03 * h15 + -1.2711800281e-03 * h16 + 4.7301581709e-05 * h17 + 9.5973366395e-04 * h18 + -4.9374008483e-04 * h19 + 1.1283696115e-04 * h20 + -3.5675697244e-04 * h21 + 1.0491421978e-03 * h22 + 3.4592993829e-04 * h23 + -7.9527253193e-04 * h24 + 3.0962110560e-04 * h25 + -7.5955232817e-04 * h26 + -6.2413201488e-04 * h27 + 7.1451461455e-04 * h28 + 7.1654857666e-04 * h29 + -2.5851413439e-03 * h30 + 2.6444543005e-06 * h31);
    k4 = tanh(-1.5472452310e-01 + -2.9574709394e-02 * h0 + -7.2850787926e-03 * h1 + 1.3958441444e-02 * h2 + 3.7814214351e-02 * h3 + -2.4021397470e-02 * h4 + 1.1504609196e-02 * h5 + -2.9053783447e-02 * h6 + -2.3819924905e-02 * h7 + 3.0999905895e-03 * h8 + -1.0143585806e-02 * h9 + 1.6447481988e-02 * h10 + 5.0406296376e-02 * h11 + 1.1189277125e-01 * h12 + -1.6623812852e-02 * h13 + 1.8663822429e-02 * h14 + -1.6654133729e-02 * h15 + -1.8293271992e-02 * h16 + 2.1433881794e-02 * h17 + -5.0137871904e-02 * h18 + -1.1204690018e-02 * h19 + -4.1491243539e-03 * h20 + -2.6137610050e-02 * h21 + 1.0586040439e-02 * h22 + 4.0216273548e-02 * h23 + -5.8074823585e-03 * h24 + -2.6815402735e-02 * h25 + 1.8444829903e-02 * h26 + -1.6471773050e-02 * h27 + 1.9338584490e-02 * h28 + -3.9610614231e-02 * h29 + -7.0248602381e-03 * h30 + -2.4393267549e-02 * h31);
    k5 = tanh(2.3742032991e-02 + 2.6730492901e-03 * h0 + -2.3419799100e-03 * h1 + 1.0056850318e-03 * h2 + -1.1536488830e-03 * h3 + 2.9316367749e-04 * h4 + 5.7196028979e-04 * h5 + 9.7083589614e-03 * h6 + -1.3886794187e-03 * h7 + -2.2007049137e-03 * h8 + -1.2204690147e-03 * h9 + 2.0298718128e-03 * h10 + -2.3823321086e-03 * h11 + -3.6532857205e-03 * h12 + 3.6218183079e-04 * h13 + -2.0003718996e-04 * h14 + 3.6567376852e-03 * h15 + -2.0370510335e-03 * h16 + 1.7211382599e-04 * h17 + 1.6070519493e-03 * h18 + -8.2200671752e-04 * h19 + 4.6587019627e-04 * h20 + -5.7634035561e-04 * h21 + 1.4977349755e-03 * h22 + -1.7340717378e-03 * h23 + -1.2008083795e-03 * h24 + 2.6092366278e-04 * h25 + -1.1293894525e-03 * h26 + -6.0547480086e-04 * h27 + 1.1453983047e-03 * h28 + 1.9027104969e-03 * h29 + -3.8999138325e-03 * h30 + -4.4650596591e-05 * h31);
    k6 = tanh(-9.1118235592e-02 + 1.4598810295e-02 * h0 + -5.7443479360e-02 * h1 + -5.7076365321e-02 * h2 + -3.2686285400e-02 * h3 + -1.3042012816e-02 * h4 + -3.3050173639e-03 * h5 + -1.2406914792e-01 * h6 + 3.7749837712e-02 * h7 + -1.2449103105e-02 * h8 + -1.4760840826e-03 * h9 + -5.9944458946e-02 * h10 + -7.0057785631e-02 * h11 + -1.3846166071e-01 * h12 + -1.6019730460e-02 * h13 + -2.8325084704e-02 * h14 + 4.2873669366e-02 * h15 + 5.6789652406e-04 * h16 + -5.4579245547e-03 * h17 + 3.6988663889e-02 * h18 + 1.0403366154e-02 * h19 + -2.9623167336e-02 * h20 + 2.2474683049e-02 * h21 + -4.2398352669e-02 * h22 + -5.6985557015e-02 * h23 + -5.9762588696e-02 * h24 + 5.0410111992e-02 * h25 + 4.5226808731e-02 * h26 + 1.7918822057e-02 * h27 + -2.3893890561e-02 * h28 + -2.6787832073e-02 * h29 + -5.4684466221e-02 * h30 + 7.0373538190e-03 * h31);
    k7 = tanh(-1.5702869099e-01 + -1.1673516485e-01 * h0 + -5.8994172382e-02 * h1 + 1.4428674382e-01 * h2 + 1.9244569295e-01 * h3 + -1.4154059428e-01 * h4 + 4.1643889043e-02 * h5 + 1.6648732049e-01 * h6 + -4.6503365821e-02 * h7 + 4.9682930941e-02 * h8 + -2.0984585503e-02 * h9 + 4.9850614603e-02 * h10 + 1.0461447943e-01 * h11 + 2.0588035303e-01 * h12 + 1.5806215255e-02 * h13 + 2.5172135616e-03 * h14 + -1.1981752432e-01 * h15 + -8.6861840524e-02 * h16 + -3.9566036215e-02 * h17 + -5.2756205049e-03 * h18 + -6.2663176850e-02 * h19 + 7.1042751614e-02 * h20 + -6.1289249839e-02 * h21 + -7.3830870399e-02 * h22 + 4.4941715542e-02 * h23 + 5.9031468812e-02 * h24 + -1.9491069857e-01 * h25 + -1.8499010884e-02 * h26 + -1.2859514738e-01 * h27 + -2.9289136968e-02 * h28 + 4.1329885077e-02 * h29 + 1.6171784150e-01 * h30 + 1.3075239312e-01 * h31);
    k8 = tanh(4.1266297785e-02 + -2.0966516897e-01 * h0 + -3.4314630028e-02 * h1 + -9.3065133641e-01 * h2 + 2.3532330263e-01 * h3 + 9.0579491607e-02 * h4 + -5.3079407810e-01 * h5 + -5.2295784997e-03 * h6 + 1.0528008060e-01 * h7 + -2.4541583970e-01 * h8 + 4.2925029229e-01 * h9 + -3.2976143899e-01 * h10 + -1.3234632677e-01 * h11 + -2.1551553885e-02 * h12 + 1.6635390542e-01 * h13 + 6.2013944037e-01 * h14 + -6.7763145895e-01 * h15 + -1.1169930353e-02 * h16 + 6.6267178973e-02 * h17 + 2.8296748717e-01 * h18 + 3.8770269635e-01 * h19 + 2.1862905914e-01 * h20 + 1.6014627251e-01 * h21 + -1.6369832439e-01 * h22 + -1.3449234222e-01 * h23 + -2.2887396140e-01 * h24 + 2.2977920101e-02 * h25 + 2.8058978532e-01 * h26 + -9.2177515037e-02 * h27 + -1.7440492759e-01 * h28 + 4.2402664246e-02 * h29 + -7.7109052552e-02 * h30 + -1.3265192344e-01 * h31);
    k9 = tanh(5.1786495893e-02 + -1.2723299604e-01 * h0 + -1.3533300253e-01 * h1 + 2.2822224705e-02 * h2 + -2.9413936610e-01 * h3 + 1.1202979289e-01 * h4 + -1.2677850500e-02 * h5 + 1.0736293246e-01 * h6 + 3.7626140124e-02 * h7 + -1.8027126558e-01 * h8 + -1.2703615706e-01 * h9 + -2.2013855303e-01 * h10 + -2.1131561170e-01 * h11 + 3.5700490255e-02 * h12 + 2.9664237870e-01 * h13 + 6.2818487473e-02 * h14 + 6.4816497470e-02 * h15 + 8.2412607139e-02 * h16 + -1.5636978619e-01 * h17 + -1.4560503004e-01 * h18 + 4.2503174364e-01 * h19 + -5.5234911220e-02 * h20 + 1.7036710039e-01 * h21 + -1.1329648143e-01 * h22 + 2.1089273166e-01 * h23 + -4.8045562622e-02 * h24 + 3.0789455963e-02 * h25 + -1.4869965570e-02 * h26 + 1.6521981811e-01 * h27 + -6.0423971338e-03 * h28 + 1.0538084409e-01 * h29 + -1.6274500837e-01 * h30 + -3.1104289907e-02 * h31);
    k10 = tanh(-3.8458709143e-02 + -5.6267537916e-03 * h0 + 2.8781770593e-03 * h1 + -1.4083755970e-03 * h2 + 1.7650363558e-03 * h3 + -4.4269316454e-03 * h4 + -5.2749434894e-05 * h5 + -5.1106468374e-03 * h6 + 2.5570353273e-03 * h7 + 4.2945480665e-03 * h8 + 1.5717871943e-03 * h9 + -3.1114996302e-03 * h10 + 4.4114871087e-03 * h11 + 7.8300693738e-03 * h12 + -5.4784225599e-05 * h13 + 1.1965339519e-03 * h14 + -6.8379257311e-03 * h15 + 3.6374046502e-03 * h16 + -1.6843562036e-04 * h17 + -2.8587115301e-03 * h18 + 1.3338872832e-03 * h19 + 5.1050874012e-05 * h20 + 1.0423811158e-03 * h21 + -2.9766224138e-03 * h22 + -1.0810821983e-03 * h23 + 2.4206526621e-03 * h24 + -1.1004887026e-03 * h25 + 2.1357305759e-03 * h26 + 1.8637170496e-03 * h27 + -2.0809378403e-03 * h28 + -2.1914395981e-03 * h29 + 7.5067877315e-03 * h30 + 2.3072869303e-04 * h31);
    k11 = tanh(-5.1664179601e-02 + -3.7808866394e-02 * h0 + -1.1548395560e-03 * h1 + -1.0709822786e-01 * h2 + -1.1745534671e-01 * h3 + -1.6122111849e-02 * h4 + 6.1962857127e-02 * h5 + -1.8068456137e-01 * h6 + 1.3642942542e-02 * h7 + -4.4758278747e-02 * h8 + 5.1130703243e-02 * h9 + -9.1017623562e-02 * h10 + -1.0592138127e-01 * h11 + -1.2428357927e-01 * h12 + 6.9635668079e-02 * h13 + -7.8960306210e-03 * h14 + -1.3142449214e-01 * h15 + 1.2971617943e-01 * h16 + 2.3706147379e-02 * h17 + 8.6056402876e-02 * h18 + 7.4003094026e-03 * h19 + -1.0392282530e-02 * h20 + 6.2639412100e-02 * h21 + -6.9110610388e-02 * h22 + 1.3468940680e-01 * h23 + -2.1991800467e-02 * h24 + 1.3146953581e-01 * h25 + 3.9034145439e-02 * h26 + 3.0797873422e-02 * h27 + -2.1915106825e-02 * h28 + 1.3267349314e-01 * h29 + -9.0447741286e-03 * h30 + -1.0615331665e-01 * h31);
    k12 = tanh(-2.0970452361e-01 + 6.1321510123e-02 * h0 + 7.4389035558e-02 * h1 + -8.9787703306e-03 * h2 + 1.8806821345e-02 * h3 + 3.9171088846e-02 * h4 + 4.7866134185e-02 * h5 + 1.9576704607e-02 * h6 + -4.7395204147e-02 * h7 + 1.0562932845e-01 * h8 + 2.7825312026e-02 * h9 + 1.9641451198e-01 * h10 + -6.7764640984e-02 * h11 + 1.9725604351e-01 * h12 + -9.3345762007e-02 * h13 + 1.0877333754e-01 * h14 + 1.2925035301e-02 * h15 + -3.1269412523e-03 * h16 + 2.2762630855e-02 * h17 + -1.2271367134e-01 * h18 + -3.4784034980e-02 * h19 + -4.4547881553e-02 * h20 + -1.4871217190e-02 * h21 + 4.9954775145e-02 * h22 + 4.8961537707e-02 * h23 + 7.7445444585e-02 * h24 + -9.2732191979e-02 * h25 + -3.5983228557e-02 * h26 + -9.3717384672e-02 * h27 + -2.1441641968e-03 * h28 + -1.1076879806e-01 * h29 + 2.0361747635e-01 * h30 + 1.3716369692e-02 * h31);
    k13 = tanh(-1.8349389388e-01 + 1.8177865474e-01 * h0 + 6.0947981529e-03 * h1 + 1.2120948517e-01 * h2 + 1.4566135210e-01 * h3 + -1.0275217323e-01 * h4 + 2.4586692518e-01 * h5 + -7.3268514390e-02 * h6 + -1.3750714504e-01 * h7 + 1.1115745236e-01 * h8 + -1.1329396479e-02 * h9 + 1.7754378784e-01 * h10 + 8.8911931992e-02 * h11 + 1.4034206038e-01 * h12 + -2.1194657457e-02 * h13 + -1.5297848021e-01 * h14 + 8.9145933541e-02 * h15 + -1.5392268461e-01 * h16 + 1.2933055922e-01 * h17 + -2.1391763126e-01 * h18 + -2.3048593133e-01 * h19 + -1.2665433837e-01 * h20 + -5.3070994450e-02 * h21 + 7.3672032686e-02 * h22 + -5.7255334467e-02 * h23 + 1.5246926564e-01 * h24 + -2.3513030881e-02 * h25 + -3.5446336435e-02 * h26 + -1.0214363402e-01 * h27 + 5.1458127049e-02 * h28 + 1.9968931910e-02 * h29 + 1.1192222054e-01 * h30 + 1.9172055484e-02 * h31);
    k14 = tanh(9.4362870910e-02 + -1.8004589583e-01 * h0 + -1.2105494623e-01 * h1 + -1.5614042304e-01 * h2 + -5.2261759953e-02 * h3 + 1.0028878421e-01 * h4 + 5.5917078162e-02 * h5 + -1.2054201176e-01 * h6 + 5.7612089692e-02 * h7 + -1.9637990614e-01 * h8 + 1.5103325590e-01 * h9 + -1.0004445276e-01 * h10 + -9.8234072101e-02 * h11 + -5.0323802356e-02 * h12 + 1.0081251475e-01 * h13 + -8.2452954141e-02 * h14 + 8.3682600565e-02 * h15 + 1.6679161949e-01 * h16 + 1.0348154472e-01 * h17 + 9.1589620839e-02 * h18 + 1.6058489119e-01 * h19 + 2.0744330358e-02 * h20 + -3.8739354587e-02 * h21 + -1.3779876721e-02 * h22 + 1.0808079933e-01 * h23 + -1.6149167414e-01 * h24 + -5.1877375640e-02 * h25 + 2.7373859452e-02 * h26 + -6.9976808473e-02 * h27 + -1.9472704398e-02 * h28 + -1.3125087495e-01 * h29 + 4.0358069717e-02 * h30 + -1.8042828935e-01 * h31);
    k15 = tanh(-1.5179436601e-01 + -8.5261410857e-04 * h0 + -1.0885095250e-01 * h1 + 1.6238331469e-01 * h2 + 1.3134135870e-01 * h3 + -8.1896708615e-02 * h4 + 6.8802623741e-02 * h5 + 1.9771732047e-01 * h6 + -1.4993481536e-01 * h7 + 1.7462941827e-01 * h8 + -5.9208339042e-03 * h9 + 1.9685866239e-01 * h10 + -4.1502827707e-02 * h11 + 8.0769866965e-02 * h12 + -9.1329260820e-02 * h13 + 2.7611988868e-02 * h14 + 1.2297119545e-03 * h15 + 1.2191698530e-01 * h16 + 4.3023181796e-04 * h17 + -1.1895593423e-03 * h18 + -2.2599377468e-01 * h19 + -9.1412079185e-02 * h20 + -3.7702546488e-02 * h21 + 1.0877930564e-01 * h22 + 1.1065191771e-01 * h23 + 4.9362528594e-02 * h24 + -5.2848091854e-02 * h25 + -4.3041361331e-02 * h26 + -1.0235178841e-01 * h27 + 1.8446068827e-01 * h28 + -8.4570730282e-02 * h29 + 2.2382414845e-01 * h30 + 8.3943997760e-02 * h31);
    k16 = tanh(1.5151405590e-01 + -7.9356564401e-03 * h0 + -1.9808852158e-02 * h1 + 8.4878038240e-03 * h2 + -4.1207647404e-02 * h3 + 2.7422169988e-02 * h4 + -3.9234505300e-03 * h5 + -3.5456066770e-02 * h6 + -1.6750239716e-02 * h7 + -3.0209000131e-02 * h8 + 1.9935287269e-04 * h9 + 3.2722655303e-03 * h10 + -2.0848956655e-02 * h11 + -6.4193760170e-02 * h12 + 1.2587612492e-03 * h13 + -1.2443654782e-02 * h14 + 1.3458535443e-02 * h15 + -4.7166373222e-03 * h16 + -3.6435636961e-03 * h17 + 3.2259993033e-02 * h18 + -4.7103809430e-03 * h19 + -8.0525516196e-04 * h20 + 1.7232360554e-02 * h21 + -1.1393063243e-03 * h22 + 2.5235047091e-02 * h23 + -2.3116193567e-02 * h24 + 1.5369597619e-02 * h25 + 8.6898177819e-05 * h26 + -1.0734311186e-03 * h27 + -1.6473406353e-02 * h28 + 9.7532695904e-03 * h29 + -4.5832003341e-02 * h30 + 7.3788559738e-03 * h31);
    k17 = tanh(-1.6955452404e-01 + 1.3200594901e-01 * h0 + 1.7888601736e-01 * h1 + 7.8540768398e-02 * h2 + 1.2550248086e-01 * h3 + -2.0175730583e-02 * h4 + -1.6957747120e-02 * h5 + 1.4510570979e-01 * h6 + 1.3307208601e-02 * h7 + -2.0107077668e-02 * h8 + 1.3063712741e-01 * h9 + 1.6890503544e-01 * h10 + -1.6569628941e-03 * h11 + 2.1149109955e-01 * h12 + 4.7310000468e-02 * h13 + -7.4918121152e-02 * h14 + -1.1551315629e-01 * h15 + -1.6928135698e-01 * h16 + -6.1511472256e-02 * h17 + -4.4595323559e-04 * h18 + -3.0709137020e-01 * h19 + -1.4235087718e-01 * h20 + -8.3442125338e-02 * h21 + 7.9484046491e-02 * h22 + -1.0861617509e-01 * h23 + 6.3775306907e-02 * h24 + -8.1045044744e-02 * h25 + 8.3362034937e-02 * h26 + 1.0387684160e-02 * h27 + 9.7264191075e-02 * h28 + -6.8230427793e-02 * h29 + 1.0323833599e-01 * h30 + 1.2093176115e-03 * h31);
    k18 = tanh(-8.5297965382e-02 + -4.4472949093e-02 * h0 + 1.7886518866e-02 * h1 + -1.0847955541e-01 * h2 + 1.6111979544e-01 * h3 + 7.5435858536e-02 * h4 + -2.2029343222e-02 * h5 + 1.3069798611e-01 * h6 + 1.5922697827e-02 * h7 + 1.8131118245e-02 * h8 + 2.5520595758e-02 * h9 + 9.5269458461e-02 * h10 + -6.1444550325e-02 * h11 + 8.3299623971e-02 * h12 + -1.8701336076e-01 * h13 + 4.4998940528e-02 * h14 + -7.9125642467e-03 * h15 + 5.2756204801e-02 * h16 + 5.6842058731e-02 * h17 + 4.0265529404e-03 * h18 + -1.7118847635e-01 * h19 + -2.9886249771e-02 * h20 + -4.7182955269e-02 * h21 + 2.2540359206e-02 * h22 + -5.6845868765e-02 * h23 + -1.0534916502e-01 * h24 + 7.7176220532e-03 * h25 + -6.1687771223e-02 * h26 + 1.1259894580e-02 * h27 + -1.0668552701e-02 * h28 + -3.8635245957e-02 * h29 + 1.7273792335e-01 * h30 + 6.9770032790e-02 * h31);
    k19 = tanh(-1.4121087403e-01 + 1.4860886518e-02 * h0 + 9.1336471158e-02 * h1 + 6.6951861788e-04 * h2 + -2.4183727893e-02 * h3 + 7.0538973600e-02 * h4 + 5.8378046805e-02 * h5 + 6.4552510906e-02 * h6 + -4.5850531167e-02 * h7 + -2.4383004827e-02 * h8 + 5.6250859620e-03 * h9 + 3.6810144693e-02 * h10 + 2.5922984329e-02 * h11 + 1.0644650960e-01 * h12 + 1.1819368335e-02 * h13 + -3.1102932238e-03 * h14 + -2.6135497036e-03 * h15 + -7.1765679278e-02 * h16 + -1.8655369062e-02 * h17 + 2.5918672103e-02 * h18 + -9.7178125499e-03 * h19 + 1.0793928523e-02 * h20 + -3.5986758087e-02 * h21 + 3.2108658283e-02 * h22 + -9.7277018255e-02 * h23 + 4.9518467022e-02 * h24 + -1.0151755876e-01 * h25 + -1.7562376566e-02 * h26 + 5.9656099052e-02 * h27 + -1.1408551624e-02 * h28 + -4.6459688911e-02 * h29 + 1.9740754987e-01 * h30 + -1.5524544053e-02 * h31);
    k20 = tanh(-8.1524587621e-04 + -1.7378720432e-02 * h0 + -3.8604471880e-03 * h1 + 7.6400518592e-02 * h2 + -1.1241090878e-01 * h3 + -9.2243718701e-02 * h4 + 3.8638402997e-02 * h5 + 5.9620479325e-02 * h6 + -1.8984982512e-01 * h7 + -1.3781896927e-03 * h8 + 6.9377863791e-02 * h9 + -1.6297403881e-01 * h10 + -2.4406632975e-01 * h11 + -1.8254000581e-01 * h12 + 3.8830843134e-01 * h13 + -1.0541235738e-01 * h14 + 1.1168180748e-02 * h15 + 5.3487687932e-02 * h16 + -7.2441185684e-02 * h17 + -2.2057424169e-02 * h18 + 3.5392753332e-01 * h19 + 5.8001300316e-02 * h20 + 5.9547082319e-02 * h21 + -8.2008836002e-02 * h22 + -5.6275789727e-03 * h23 + -1.3242532881e-01 * h24 + -8.9657391008e-02 * h25 + 1.0789908672e-01 * h26 + 1.0779804129e-01 * h27 + 8.5208166623e-02 * h28 + 9.1507476103e-02 * h29 + -2.1881995382e-01 * h30 + -7.9527664769e-02 * h31);
    k21 = tanh(1.2004554222e-01 + 2.9054370734e-03 * h0 + -2.2730451935e-03 * h1 + 2.8272718645e-02 * h2 + -2.9680321246e-02 * h3 + 8.8110092778e-02 * h4 + 1.1744911989e-02 * h5 + -1.9779142112e-02 * h6 + 2.3990010720e-02 * h7 + -3.5403873913e-02 * h8 + 1.7028007242e-02 * h9 + -2.2710180178e-02 * h10 + -1.5809430094e-02 * h11 + -1.1206676504e-02 * h12 + 1.4066317587e-02 * h13 + 1.0374579009e-03 * h14 + -4.6036116169e-02 * h15 + 7.4667240344e-02 * h16 + 6.7384546388e-03 * h17 + 5.5353749861e-02 * h18 + 3.5100208202e-03 * h19 + 3.3401001323e-03 * h20 + 1.5468302441e-02 * h21 + -3.3153487949e-02 * h22 + 7.3686962567e-02 * h23 + -2.5631497225e-02 * h24 + 2.7081180930e-02 * h25 + -5.3290007186e-02 * h26 + 1.3721913707e-03 * h27 + -4.3101905100e-02 * h28 + 7.9748740800e-02 * h29 + -2.8476477915e-02 * h30 + -1.1578144187e-02 * h31);
    k22 = tanh(-2.2075412726e-02 + 7.6541735139e-02 * h0 + -7.8425507865e-02 * h1 + -2.0465354276e-01 * h2 + -1.3017652642e-01 * h3 + 3.2485708635e-02 * h4 + -2.4625361328e-01 * h5 + -2.1389834777e-02 * h6 + -2.0669310403e-02 * h7 + -1.4916403885e-01 * h8 + 1.0487274280e-01 * h9 + -2.6503808684e-02 * h10 + -1.9993217091e-01 * h11 + -2.0493181340e-01 * h12 + 2.4145814058e-02 * h13 + 1.7513299771e-01 * h14 + 3.4975871165e-04 * h15 + 3.1300584528e-02 * h16 + -4.6940659492e-02 * h17 + 1.3064903877e-01 * h18 + 1.9292535819e-01 * h19 + 2.1994344687e-01 * h20 + 2.0262255108e-01 * h21 + 8.7584470210e-02 * h22 + -1.3907714584e-01 * h23 + -3.1160888042e-02 * h24 + 5.6288142983e-02 * h25 + 1.7386215246e-01 * h26 + 1.1785549662e-01 * h27 + -1.2270245336e-01 * h28 + 5.9460318419e-03 * h29 + 2.9826937733e-02 * h30 + -1.3282194341e-01 * h31);
    k23 = tanh(2.4657491291e-03 + 1.6323619268e-03 * h0 + -1.8084881694e-03 * h1 + 3.8120199852e-04 * h2 + -2.1237369041e-04 * h3 + -1.6161267147e-04 * h4 + 8.8346094609e-03 * h5 + -1.9073398035e-03 * h6 + 2.3763796027e-03 * h7 + 4.8957092562e-03 * h8 + -4.8462308844e-03 * h9 + 5.7454919581e-04 * h10 + -1.6091301223e-03 * h11 + 7.9721486575e-05 * h12 + 5.0903160095e-03 * h13 + 7.0952225720e-03 * h14 + -2.8374074304e-03 * h15 + 2.3196288621e-03 * h16 + 2.0716408785e-03 * h17 + -1.7216942601e-03 * h18 + 2.3915473906e-04 * h19 + 5.9152551201e-03 * h20 + -2.4586258683e-03 * h21 + -5.1032864393e-03 * h22 + -3.0435977510e-03 * h23 + 5.8585659077e-03 * h24 + -5.8500956905e-03 * h25 + 2.4734452788e-03 * h26 + 2.5035147357e-03 * h27 + -8.1085515607e-04 * h28 + -5.0052483620e-03 * h29 + 9.1012788326e-05 * h30 + -3.9007215300e-03 * h31);
    k24 = tanh(-1.7798753515e-01 + 1.7756503305e-02 * h0 + 1.2914269297e-01 * h1 + 9.4055413773e-03 * h2 + 1.4356248383e-01 * h3 + -4.3249865866e-02 * h4 + 2.8898953313e-02 * h5 + 8.1345703025e-02 * h6 + 5.5057578942e-03 * h7 + -2.0668010083e-02 * h8 + -5.4262892534e-02 * h9 + 3.0110255595e-02 * h10 + 1.0853423235e-01 * h11 + -1.2444003956e-02 * h12 + -4.6497228278e-02 * h13 + 6.1330045651e-03 * h14 + -8.9391262029e-03 * h15 + 1.3440142697e-02 * h16 + 3.8048606304e-02 * h17 + -1.5249600264e-01 * h18 + -1.5970311845e-01 * h19 + -1.0825802230e-02 * h20 + -1.5687134372e-02 * h21 + 8.2526880207e-02 * h22 + -7.8241436214e-02 * h23 + -8.2115817804e-03 * h24 + -8.3577887077e-02 * h25 + 7.2746611320e-02 * h26 + -6.4929141890e-02 * h27 + 5.9530933665e-02 * h28 + -3.9585938063e-02 * h29 + 1.1769197076e-01 * h30 + -2.6847678536e-02 * h31);
    k25 = tanh(2.7742212533e-04 + -2.7228431799e-04 * h0 + 2.9158740555e-04 * h1 + -2.1586394056e-04 * h2 + 1.0111401848e-04 * h3 + -7.0295169731e-05 * h4 + -7.9033652239e-04 * h5 + 9.5815160247e-05 * h6 + -6.3081522524e-05 * h7 + -2.3494211215e-04 * h8 + 5.8081516383e-04 * h9 + -1.6167609458e-04 * h10 + 2.6442074512e-04 * h11 + 1.0557079369e-04 * h12 + -4.1650070939e-04 * h13 + -6.5217646311e-04 * h14 + 4.3585901309e-05 * h15 + -1.2332737239e-04 * h16 + -1.7393994176e-04 * h17 + 8.9172135497e-05 * h18 + 1.1080702368e-05 * h19 + -5.2788422655e-04 * h20 + 2.6047890456e-04 * h21 + 3.3370796783e-04 * h22 + 2.8866769511e-04 * h23 + -4.9861089403e-04 * h24 + 5.3655202889e-04 * h25 + -9.8553685042e-05 * h26 + -1.7349055597e-04 * h27 + 8.1246955269e-06 * h28 + 4.6325392147e-04 * h29 + 1.2325360627e-04 * h30 + 1.9824148342e-04 * h31);
    k26 = tanh(-3.9877586773e-02 + 5.6701374525e-02 * h0 + -7.3350977162e-02 * h1 + -4.8412207307e-02 * h2 + 5.1701206124e-02 * h3 + 7.9994076978e-02 * h4 + -5.2249107396e-02 * h5 + 3.5952083731e-02 * h6 + 4.3083241102e-02 * h7 + 1.9875964877e-02 * h8 + 8.4680003354e-03 * h9 + -5.0390579080e-02 * h10 + -1.9374564035e-02 * h11 + -1.2294933855e-01 * h12 + -3.0503632359e-02 * h13 + 6.4263766736e-03 * h14 + 5.7235727738e-02 * h15 + 1.0201220908e-01 * h16 + -1.5313847468e-02 * h17 + 9.6744760683e-03 * h18 + 2.1464369575e-02 * h19 + -2.5528208454e-02 * h20 + 2.5254890516e-02 * h21 + -2.8318704988e-04 * h22 + -5.6593847149e-02 * h23 + -7.1753284138e-02 * h24 + 4.2198808274e-02 * h25 + 5.7139292770e-02 * h26 + 5.0243264552e-02 * h27 + -6.6200971194e-02 * h28 + 6.2208381642e-02 * h29 + -1.5575957835e-01 * h30 + -9.0576473849e-03 * h31);
    k27 = tanh(8.0314710967e-02 + 6.7631426345e-02 * h0 + 5.0797073824e-02 * h1 + 1.1637532340e-01 * h2 + 3.8730309895e-02 * h3 + 9.8461811950e-02 * h4 + -1.1023189048e-01 * h5 + 1.0704423310e-01 * h6 + 2.8334894945e-02 * h7 + 7.2147898479e-02 * h8 + -1.2018216525e-01 * h9 + 6.1076710601e-02 * h10 + -9.9558576823e-03 * h11 + 1.6729983959e-01 * h12 + -5.9193661947e-02 * h13 + 5.7030206614e-02 * h14 + 1.4221295816e-01 * h15 + 1.0923641186e-01 * h16 + -1.1351730169e-01 * h17 + -9.0436529982e-02 * h18 + -9.7476311416e-02 * h19 + 5.5586394716e-02 * h20 + -3.4007914165e-02 * h21 + 1.7013143703e-01 * h22 + 7.4707347428e-02 * h23 + 1.5892631353e-01 * h24 + -8.6651524961e-02 * h25 + 1.1373458217e-02 * h26 + -7.8652476528e-02 * h27 + 1.0887033435e-01 * h28 + 2.1947403541e-02 * h29 + 1.3850385530e-01 * h30 + 1.5608431730e-01 * h31);
    k28 = tanh(1.7260346677e-01 + -5.1795243267e-02 * h0 + -1.6657137977e-02 * h1 + -1.0598502141e-02 * h2 + -7.8959635733e-02 * h3 + 1.1350791190e-02 * h4 + -6.3148222169e-02 * h5 + 2.6714164131e-02 * h6 + -8.8561669466e-03 * h7 + -9.0900104215e-02 * h8 + -7.2917841642e-03 * h9 + -6.0014836049e-02 * h10 + -1.9022423477e-02 * h11 + -1.5267658593e-01 * h12 + 5.1576637683e-02 * h13 + -5.9171916963e-02 * h14 + -1.2369579895e-02 * h15 + 6.2052291023e-02 * h16 + -2.9536458709e-02 * h17 + 8.4408163913e-02 * h18 + 4.1037053380e-02 * h19 + 8.8044672723e-03 * h20 + 6.4755663744e-02 * h21 + -2.2296099336e-02 * h22 + 2.9556946445e-02 * h23 + -2.0125671646e-02 * h24 + 8.2154153869e-02 * h25 + 6.7606264515e-02 * h26 + -1.3574874434e-02 * h27 + -8.5467784771e-02 * h28 + 3.4960307596e-02 * h29 + -9.9866308944e-02 * h30 + 6.5114569823e-02 * h31);
    k29 = tanh(6.2257779923e-02 + 2.8341717529e-02 * h0 + 1.4582751158e-03 * h1 + -8.5353680554e-02 * h2 + 2.7215156498e-01 * h3 + -2.4889018050e-02 * h4 + -1.9511087847e-02 * h5 + 1.4484719448e-01 * h6 + 2.0835854097e-01 * h7 + 8.0457731901e-02 * h8 + 4.8782684893e-02 * h9 + 3.5939945238e-02 * h10 + 1.8417448227e-01 * h11 + 6.6468928336e-02 * h12 + -4.8279010101e-01 * h13 + -5.7478391797e-02 * h14 + -1.6249252694e-02 * h15 + 1.2299474418e-01 * h16 + -6.4406290315e-02 * h17 + 6.5866124315e-02 * h18 + -3.4481332019e-01 * h19 + -6.2451468209e-03 * h20 + -1.0996905770e-01 * h21 + 1.3145448661e-01 * h22 + 2.3039727718e-02 * h23 + 1.4977028787e-01 * h24 + -1.3148762003e-01 * h25 + 7.9770647461e-02 * h26 + -1.1460812298e-01 * h27 + 1.0005930485e-01 * h28 + -5.0162610988e-02 * h29 + 2.6646378639e-01 * h30 + 9.4639713672e-02 * h31);
    k30 = tanh(-5.7587120143e-02 + -3.2075284367e-02 * h0 + 6.0891590424e-02 * h1 + -7.1107505465e-03 * h2 + 1.4123516954e-02 * h3 + -5.7303015322e-02 * h4 + -2.3741548980e-02 * h5 + -6.5035896694e-02 * h6 + 2.2558226598e-02 * h7 + 5.5985874818e-02 * h8 + 4.6758055877e-02 * h9 + -5.5288989850e-02 * h10 + -4.6515340292e-02 * h11 + -1.2669039115e-01 * h12 + 7.8815128048e-04 * h13 + -1.1182386886e-02 * h14 + 1.7638976003e-02 * h15 + 3.1950042081e-04 * h16 + -2.1258903270e-02 * h17 + 6.0205001102e-02 * h18 + 2.9543697090e-02 * h19 + -9.6904084240e-03 * h20 + 2.6048394287e-02 * h21 + -7.1533157679e-02 * h22 + 6.4765841385e-02 * h23 + -6.1800239361e-02 * h24 + 3.3982064945e-02 * h25 + 4.1108883083e-02 * h26 + 4.7404725708e-02 * h27 + -8.2072622422e-02 * h28 + 1.9772930346e-02 * h29 + -1.8985669076e-02 * h30 + -5.4548696755e-03 * h31);
    k31 = tanh(-6.0843486039e-02 + 6.6509324660e-02 * h0 + -1.2554500204e-02 * h1 + -5.7582112301e-03 * h2 + 1.9900992905e-02 * h3 + -4.1743107829e-02 * h4 + -1.2292943541e-04 * h5 + 3.8232787731e-02 * h6 + 3.5255522351e-03 * h7 + 2.9889023119e-02 * h8 + -5.8466500407e-03 * h9 + 1.8101370383e-02 * h10 + 6.3519929959e-03 * h11 + 5.4216515206e-02 * h12 + -4.2310043514e-03 * h13 + 2.0414103484e-03 * h14 + 8.1352477809e-03 * h15 + -2.3724501430e-02 * h16 + 4.7580263500e-03 * h17 + -5.5521969666e-03 * h18 + 2.6647946134e-03 * h19 + -7.3619043410e-03 * h20 + -2.4356051528e-02 * h21 + -1.1075789090e-02 * h22 + -4.8194064907e-03 * h23 + 1.3541527852e-02 * h24 + -6.2899523853e-03 * h25 + -3.1733015101e-03 * h26 + -1.8575926143e-02 * h27 + 1.5323622162e-02 * h28 + -2.6460730000e-02 * h29 + 8.0471993304e-02 * h30 + -8.3759893848e-03 * h31);
    acc = -4.6179133707e-02 + -2.8232993317e-04 * k0 + 2.0556105074e-01 * k1 + 1.3238104417e-01 * k2 + -3.9196477661e-05 * k3 + 1.5953806512e-02 * k4 + -2.1124428927e-05 * k5 + -2.8174428937e-02 * k6 + 2.0399867785e-01 * k7 + -3.8195588574e-01 * k8 + -3.3033540168e-01 * k9 + 2.2665339595e-04 * k10 + -1.3153302346e-01 * k11 + 3.1057164548e-01 * k12 + 4.4384510152e-01 * k13 + -1.9118248517e-01 * k14 + 2.2676092142e-01 * k15 + -1.2028173907e-02 * k16 + 4.1632162166e-01 * k17 + 1.7063135602e-01 * k18 + 9.7155744303e-02 * k19 + -2.5649031757e-01 * k20 + -1.7528870320e-02 * k21 + -2.6480493019e-01 * k22 + 2.2846937923e-04 * k23 + 1.7076402165e-01 * k24 + 4.1352444001e-05 * k25 + -2.8284823124e-02 * k26 + 1.8860124213e-01 * k27 + -1.8483184695e-01 * k28 + 2.8721123916e-01 * k29 + -2.3648646105e-02 * k30 + 1.4939885198e-02 * k31;
    gsum = gsum + 1 * tanh(acc);
    // ensemble member 4
    h0 = tanh(3.2547663543e-01 + -2.2585594424e-01 * x0 + 2.2760241438e-01 * x1 + -2.7944153840e-01 * x2 + -4.4334755906e-02 * x3 + -2.2627449642e-01 * x4 + -4.8282107724e-01 * x5);
    h1 = tanh(-5.6171937411e-01 + 8.3569211985e-01 * x0 + 7.2847835390e-01 * x1 + 5.3948566726e-01 * x2 + -2.8850927273e-01 * x3 + -7.6356302237e-01 * x4 + -3.6652918598e-01 * x5);
    h2 = tanh(9.4978589244e-02 + 3.4424727414e-01 * x0 + -1.6114078795e-02 * x1 + 1.2116705061e-01 * x2 + 3.3629201752e-01 * x3 + -2.0408015788e-02 * x4 + -3.2359186756e-01 * x5);
    h3 = tanh(2.3941202559e-01 + -1.3590133928e-01 * x0 + -3.1739608078e-01 * x1 + 2.6606420382e-03 * x2 + -1.0028757520e-01 * x3 + -7.3555429704e-02 * x4 + 1.3578212711e-01 * x5);
    h4 = tanh(3.0581132268e-01 + 1.1013865720e-02 * x0 + -1.1406926361e-01 * x1 + 2.7955275136e-01 * x2 + -3.1280276093e-01 * x3 + 1.3986669250e-01 * x4 + 8.4329561842e-01 * x5);
    h5 = tanh(5.1820461630e-02 + 1.3028671136e-01 * x0 + 6.1384855124e-02 * x1 + -3.8411797085e-02 * x2 + 2.9460727013e-01 * x3 + 2.2457603402e-01 * x4 + -5.1249308166e-01 * x5);
    h6 = tanh(3.8539850332e-01 + -2.9617450887e-03 * x0 + -1.6379841295e-02 * x1 + -1.7285102956e-02 * x2 + -9.8990820928e-02 * x3 + 3.0762711093e-01 * x4 + 6.5995970484e-01 * x5);
    h7 = tanh(-3.6533754095e-01 + 2.8068828423e-01 * x0 + -1.0890455669e-01 * x1 + -8.5701523090e-02 * x2 + 3.6106226131e-01 * x3 + 5.4882814715e-02 * x4 + -1.1682691187e-01 * x5);
    h8 = tanh(1.6651239658e-01 + -6.4854381812e-01 * x0 + 6.3204934900e-01 * x1 + -1.4660890052e-01 * x2 + 3.0906105088e-01 * x3 + 3.8982941899e-01 * x4 + -6.0767204064e-01 * x5);
    h9 = tanh(-3.6262636852e-01 + -3.6121497239e-01 * x0 + -2.8470834564e-02 * x1 + 2.3393401863e-02 * x2 + 2.2692561568e-01 * x3 + -7.2540396539e-02 * x4 + 5.0170111793e-01 * x5);
    h10 = tanh(1.4038320876e-01 + -3.5659944451e-01 * x0 + 4.8143438666e-02 * x1 + -8.1105072601e-01 * x2 + 3.0654416061e-01 * x3 + 3.4081755699e-02 * x4 + 6.3697513796e-01 * x5);
    h11 = tanh(3.4294006476e-01 + 1.6609145568e-01 * x0 + -3.5690430994e-01 * x1 + 1.1708217931e-01 * x2 + -2.1772203082e-02 * x3 + 8.8669237974e-02 * x4 + -4.5899685095e-01 * x5);
    h12 = tanh(-1.7756136019e-01 + -6.7199772907e-02 * x0 + -7.4183915936e-02 * x1 + -2.0658376785e-01 * x2 + 2.1547667151e-01 * x3 + 3.1494936755e-02 * x4 + 1.0475827580e-01 * x5);
    h13 = tanh(1.2264470458e-02 + -7.1459198964e-02 * x0 + -1.3361126584e-01 * x1 + 9.2331417938e-02 * x2 + 3.8435653632e-01 * x3 + 2.2228519124e-01 * x4 + -4.4614864296e-01 * x5);
    h14 = tanh(-5.1027868883e-01 + -1.5294468915e-01 * x0 + 4.1946668072e-02 * x1 + 2.7453682946e-01 * x2 + -4.2410193028e-01 * x3 + -3.6806921607e-01 * x4 + -5.9758330324e-01 * x5);
    h15 = tanh(-6.6287889778e-02 + 7.5149247178e-03 * x0 + 2.2882955493e-01 * x1 + 3.3144898885e-01 * x2 + 4.2398339335e-01 * x3 + 2.7756479869e-01 * x4 + -1.3367741892e-01 * x5);
    h16 = tanh(3.3183246464e-01 + -2.4523833092e-01 * x0 + 9.5952798006e-02 * x1 + 5.6765997295e-01 * x2 + -3.1585841378e-01 * x3 + 2.0053463705e-01 * x4 + 6.8432689408e-01 * x5);
    h17 = tanh(2.0096747387e-01 + 3.3001407423e-01 * x0 + 3.9927760829e-02 * x1 + -3.4109854349e-01 * x2 + 1.1938153577e-01 * x3 + 1.1867042698e-01 * x4 + -3.9762787135e-01 * x5);
    h18 = tanh(1.3812132412e-01 + -2.6511064072e-02 * x0 + -1.5010942714e-01 * x1 + 3.3195388228e-01 * x2 + 2.1032936879e-01 * x3 + -7.0315578058e-01 * x4 + 2.7462605153e-02 * x5);
    h19 = tanh(-2.9154277291e-01 + 6.1672706012e-02 * x0 + 1.6742379761e-01 * x1 + 1.7995308268e-02 * x2 + -1.9211964224e-01 * x3 + 1.7380017462e-01 * x4 + -5.1783247281e-01 * x5);
    h20 = tanh(-1.7473794972e-01 + 5.8684112605e-04 * x0 + -1.6367764425e-01 * x1 + -2.3652846653e-02 * x2 + 7.8043678129e-02 * x3 + 3.3741481807e-02 * x4 + -1.9629544418e-01 * x5);
    h21 = tanh(3.6185766064e-01 + 7.4502629685e-02 * x0 + 2.8143781116e-01 * x1 + 5.3141518247e-02 * x2 + 2.2090485183e-01 * x3 + 2.5208936369e-01 * x4 + 4.1840916310e-01 * x5);
    h22 = tanh(2.0904071193e-01 + -5.7731877571e-02 * x0 + -1.2362524622e-01 * x1 + 1.4723860554e-01 * x2 + 1.0140811350e-01 * x3 + -7.4628895115e-03 * x4 + 2.8866354037e-02 * x5);
    h23 = tanh(1.8407860181e-01 + 2.0557354802e-01 * x0 + -1.1541479237e-01 * x1 + 4.6518620421e-02 * x2 + -1.4811107134e-01 * x3 + -3.1898363303e-01 * x4 + 1.4590851357e-01 * x5);
    h24 = tanh(3.0655913928e-01 + 3.0603453684e-01 * x0 + 2.8911012878e-01 * x1 + 7.0890169649e-02 * x2 + -9.3368237627e-02 * x3 + 2.3947005151e-01 * x4 + 2.9269078340e-01 * x5);
    h25 = tanh(-3.5961126465e-01 + -4.5285213364e-01 * x0 + 2.0154338420e-01 * x1 + -1.8144826470e-01 * x2 + 9.1999059770e-02 * x3 + -1.5278562082e-01 * x4 + -2.7312121249e-01 * x5);
    h26 = tanh(-5.4081351930e-02 + -3.1766576507e-01 * x0 + 3.5722236335e-01 * x1 + -7.9692389817e-02 * x2 + 1.4070568809e-01 * x3 + 9.3463539723e-02 * x4 + -3.9073371348e-01 * x5);
    h27 = tanh(4.1655048097e-01 + -3.4797689158e-01 * x0 + 8.3457013056e-02 * x1 + -5.4888177986e-01 * x2 + -2.2655146291e-01 * x3 + 3.9689080556e-01 * x4 + 4.3811883513e-01 * x5);
    h28 = tanh(4.1749132620e-01 + 4.6870652068e-01 * x0 + -8.6740362627e-01 * x1 + 1.0002344637e+00 * x2 + 7.2233696404e-01 * x3 + -1.4714051864e-02 * x4 + 3.4157019815e-01 * x5);
    h29 = tanh(-5.5486111075e-01 + 2.7611397832e-03 * x0 + 2.5183761741e-01 * x1 + 1.1549384934e-01 * x2 + 1.2820932250e-01 * x3 + -1.1484231048e-01 * x4 + 6.6770159556e-01 * x5);
    h30 = tanh(-3.9752455443e-01 + 1.6537595367e-01 * x0 + 1.3861953894e-01 * x1 + -9.2916681977e-02 * x2 + -1.5444420808e-01 * x3 + 7.1443285918e-02 * x4 + -2.4024336879e-01 * x5);
    h31 = tanh(-1.3953780556e-01 + 1.3683183196e-01 * x0 + -2.9887941112e-02 * x1 + 2.1371288512e-01 * x2 + -4.3101607944e-01 * x3 + -3.4569484097e-02 * x4 + 2.7760971814e-01 * x5);
    k0 = tanh(-1.2389779280e-01 + 1.3354904199e-02 * h0 + 1.9416962197e-02 * h1 + -9.2028054026e-04 * h2 + 3.5979857644e-03 * h3 + 3.8432709263e-02 * h4 + -5.5747506876e-03 * h5 + 3.8572561651e-03 * h6 + -9.3609615215e-03 * h7 + -2.3502764022e-02 * h8 + 5.1600813571e-03 * h9 + -1.1481421456e-02 * h10 + -5.2209940930e-03 * h11 + -1.5139703356e-02 * h12 + -2.3197320885e-02 * h13 + -5.8602506474e-02 * h14 + 2.1018127654e-02 * h15 + -8.8885386664e-03 * h16 + -1.0714674990e-02 * h17 + 2.9929091272e-04 * h18 + -1.7196397752e-02 * h19 + 1.0291093614e-02 * h20 + 4.0678687171e-02 * h21 + 6.1145917103e-03 * h22 + 3.3258500390e-03 * h23 + -5.7119411621e-02 * h24 + -2.4489767571e-02 * h25 + -1.4124309388e-02 * h26 + 2.1164123874e-02 * h27 + 5.0540540124e-03 * h28 + 3.4955389612e-03 * h29 + -5.3847247066e-02 * h30 + 4.9673094117e-03 * h31);
    k1 = tanh(3.0440323021e-02 + 1.2655774892e-01 * h0 + -1.2327808793e-02 * h1 + -5.4440373950e-02 * h2 + 3.2123196544e-02 * h3 + 8.5517323657e-02 * h4 + -7.6909389160e-03 * h5 + 3.4104141994e-03 * h6 + 9.9440105496e-02 * h7 + -6.4079997845e-03 * h8 + -3.2069351509e-03 * h9 + -2.9334584731e-02 * h10 + -2.7097587847e-02 * h11 + -6.1659281405e-02 * h12 + 1.0396389598e-01 * h13 + -3.7642991378e-02 * h14 + 4.4040581279e-02 * h15 + 4.3532740046e-02 * h16 + -8.8619351035e-02 * h17 + -3.0171983903e-02 * h18 + -3.0611456021e-02 * h19 + 5.2271975344e-02 * h20 + -3.3791545814e-02 * h21 + 3.0338014438e-02 * h22 + 5.2558192973e-03 * h23 + -9.4691575442e-02 * h24 + 4.4084317871e-02 * h25 + -1.1708364247e-02 * h26 + 5.3046480382e-03 * h27 + 5.6162631401e-02 * h28 + -2.0165402736e-02 * h29 + -8.4752382633e-02 * h30 + 2.9398240149e-03 * h31);
    k2 = tanh(-8.7392283896e-02 + 1.7683957360e-01 * h0 + 1.8562827501e-02 * h1 + -3.0204355044e-02 * h2 + 3.5406408702e-02 * h3 + -7.4227105519e-03 * h4 + 8.3138845550e-02 * h5 + 8.6145199178e-02 * h6 + 1.1383732256e-01 * h7 + -3.9341181737e-02 * h8 + -1.3103610859e-02 * h9 + 3.2079783825e-02 * h10 + -2.6000500870e-02 * h11 + 9.4487015025e-02 * h12 + 1.7233125297e-01 * h13 + -4.0889473255e-02 * h14 + 1.1664228601e-01 * h15 + -1.5638316024e-02 * h16 + 4.5803467171e-02 * h17 + -1.1344899502e-01 * h18 + 2.7509371923e-02 * h19 + 8.6306296200e-02 * h20 + -1.2859556438e-01 * h21 + -2.2834444952e-02 * h22 + -8.6392509458e-02 * h23 + -8.5928285950e-02 * h24 + 4.0474700111e-03 * h25 + -3.0650688581e-02 * h26 + 3.4510836573e-02 * h27 + -1.3700438737e-01 * h28 + -6.0305223920e-02 * h29 + 5.4465269130e-02 * h30 + -4.7715606545e-02 * h31);
    k3 = tanh(1.8583131217e-02 + -9.9826817264e-02 * h0 + 6.0792959329e-02 * h1 + 1.2716459744e-02 * h2 + -5.9582202880e-02 * h3 + -1.2305883479e-01 * h4 + 1.6801813565e-02 * h5 + 1.2843790838e-02 * h6 + -8.9473903058e-02 * h7 + 9.9182970362e-02 * h8 + 2.5277807548e-02 * h9 + 2.5744701651e-02 * h10 + 4.1979630840e-03 * h11 + 7.7331755821e-02 * h12 + 5.7496328929e-04 * h13 + 9.3110030477e-02 * h14 + 3.7852054427e-02 * h15 + -7.7558326865e-02 * h16 + 2.3621638490e-02 * h17 + 2.3089649790e-02 * h18 + 4.0812733190e-02 * h19 + -2.0809764545e-02 * h20 + 5.6960820395e-02 * h21 + -4.3613326690e-02 * h22 + -4.9567941182e-02 * h23 + 3.1632471763e-02 * h24 + 9.4834305497e-02 * h25 + 2.6246550436e-02 * h26 + 5.9680114495e-03 * h27 + 2.6708962471e-02 * h28 + 7.5883437321e-03 * h29 + 8.8755660083e-02 * h30 + -5.5762849639e-02 * h31);
    k4 = tanh(1.7850451028e-01 + 1.3741454626e-01 * h0 + -1.0873943306e-01 * h1 + -3.2316409625e-02 * h2 + 1.3053905437e-01 * h3 + 1.3301108077e-01 * h4 + -3.8731904826e-02 * h5 + 1.4434989337e-01 * h6 + -1.5413255179e-02 * h7 + -1.8881473886e-01 * h8 + -1.2873881556e-01 * h9 + -9.5947866419e-02 * h10 + 3.1024780648e-03 * h11 + 1.0227297645e-02 * h12 + 1.8029007618e-01 * h13 + -5.8057956181e-02 * h14 + 9.1687394544e-02 * h15 + -4.6015474321e-02 * h16 + -8.4250394903e-02 * h17 + 7.4667079621e-02 * h18 + -6.0793874153e-02 * h19 + 9.7037474782e-02 * h20 + 4.9589552283e-02 * h21 + 9.6343300292e-02 * h22 + -1.2615517851e-02 * h23 + 7.5711344433e-02 * h24 + -1.1960737467e-01 * h25 + -1.8190843048e-01 * h26 + 5.4083430330e-02 * h27 + -5.1158847155e-02 * h28 + -3.7744421990e-02 * h29 + 3.4082309041e-02 * h30 + 2.0832789742e-02 * h31);
    k5 = tanh(2.0351853793e-01 + -1.8593115995e-01 * h0 + -2.4556881914e-02 * h1 + 7.7864221849e-02 * h2 + 2.6274794960e-02 * h3 + -7.7279015763e-02 * h4 + 9.9180920619e-02 * h5 + 4.8431593891e-02 * h6 + -1.8477054848e-02 * h7 + 2.8787528534e-02 * h8 + 5.3119270589e-03 * h9 + 1.2421951411e-01 * h10 + 1.1755577269e-01 * h11 + -1.5684572761e-02 * h12 + 3.3793297142e-02 * h13 + -1.1093778640e-02 * h14 + -5.8737009289e-02 * h15 + -1.1946062122e-01 * h16 + 2.1490403654e-01 * h17 + 9.4599916149e-02 * h18 + -4.4347356755e-02 * h19 + 2.4965365519e-02 * h20 + -2.4605274568e-02 * h21 + 6.1469473470e-03 * h22 + 4.6991737633e-02 * h23 + 8.6184302273e-02 * h24 + 8.3535461044e-02 * h25 + -4.3056482043e-02 * h26 + -5.7906605296e-03 * h27 + -6.6195733650e-02 * h28 + -6.7848237136e-02 * h29 + 1.0966826380e-01 * h30 + -1.1357881198e-01 * h31);
    k6 = tanh(-5.2084238900e-02 + -7.4002598040e-01 * h0 + -9.1538524946e-01 * h1 + -3.9389994726e-01 * h2 + 7.8321293554e-02 * h3 + 5.5940485531e-01 * h4 + -3.7426196684e-01 * h5 + 4.4572633948e-01 * h6 + -3.7243038365e-02 * h7 + -7.9794518581e-01 * h8 + 2.1384028749e-01 * h9 + 8.7933141669e-01 * h10 + -5.5899205294e-01 * h11 + -1.6018493032e-01 * h12 + -3.2929509286e-01 * h13 + -3.6583036248e-01 * h14 + -2.0906375183e-02 * h15 + 1.4555704301e-01 * h16 + -4.7558205285e-01 * h17 + -4.7713052904e-02 * h18 + -2.9526017674e-01 * h19 + -2.0486170750e-01 * h20 + 1.3618166223e-01 * h21 + -7.0302761925e-02 * h22 + 2.7626861362e-01 * h23 + 3.1512152050e-01 * h24 + -1.4950593071e-01 * h25 + -5.5273698479e-01 * h26 + 5.8884585680e-02 * h27 + 1.0431352978e+00 * h28 + 8.9525991809e-01 * h29 + -4.7126418309e-02 * h30 + 4.5441011228e-01 * h31);
    k7 = tanh(-8.7838802654e-02 + 1.3882972186e-01 * h0 + 2.7778591263e-02 * h1 + -1.8571566433e-02 * h2 + 3.6968149328e-02 * h3 + -1.3207754686e-02 * h4 + 9.9894156110e-02 * h5 + 1.2007950718e-01 * h6 + 5.3438078510e-02 * h7 + -8.3104592329e-02 * h8 + -5.1279249622e-02 * h9 + 5.1817477230e-02 * h10 + 2.9044952376e-02 * h11 + 4.4517877585e-02 * h12 + 1.1285722244e-01 * h13 + 7.2909718548e-03 * h14 + 2.2838946739e-02 * h15 + 9.8625149183e-03 * h16 + 3.4455016877e-02 * h17 + -8.5177398111e-03 * h18 + -3.2030172027e-02 * h19 + -8.5930244698e-03 * h20 + 4.1274119719e-02 * h21 + 1.0229623822e-01 * h22 + -8.4371347494e-02 * h23 + 5.0268236437e-02 * h24 + -1.2770409325e-01 * h25 + -7.5474551552e-02 * h26 + -3.4953116381e-02 * h27 + 1.1187364448e-01 * h28 + -4.3067665862e-02 * h29 + 1.5813541431e-02 * h30 + 8.4162338775e-02 * h31);
    k8 = tanh(1.8113908212e-01 + -3.2260792145e-01 * h0 + 6.6154797259e-02 * h1 + -1.0613027882e-02 * h2 + -7.7323383912e-02 * h3 + 7.4427875619e-02 * h4 + -9.4173887919e-02 * h5 + -1.5634036090e-01 * h6 + -7.4870449394e-02 * h7 + -3.7273352541e-02 * h8 + 1.3853509231e-01 * h9 + -1.0196507598e-01 * h10 + 1.2550201168e-01 * h11 + -3.8249448306e-02 * h12 + -5.1849222192e-02 * h13 + 1.1732977348e-01 * h14 + -2.0236869488e-01 * h15 + -9.7323876667e-02 * h16 + -8.5030959336e-02 * h17 + 2.4070225633e-02 * h18 + -4.7807423889e-02 * h19 + -4.2237300791e-02 * h20 + 1.4499096608e-01 * h21 + -3.1696893999e-02 * h22 + 1.6497770056e-01 * h23 + 7.5201665102e-02 * h24 + 8.4736150235e-03 * h25 + -2.5085697670e-02 * h26 + 6.1772196227e-02 * h27 + 9.7953619022e-02 * h28 + 5.2905513830e-02 * h29 + -1.5776049566e-02 * h30 + -4.7270832571e-02 * h31);
    k9 = tanh(1.8177375939e-03 + 2.4860851965e-06 * h0 + -1.9015055885e-04 * h1 + -2.6010922429e-05 * h2 + 2.2348518136e-06 * h3 + -2.7273115225e-04 * h4 + 8.1149117625e-05 * h5 + -2.5550156622e-04 * h6 + 1.6270244514e-04 * h7 + 7.2704239463e-05 * h8 + 1.1479512111e-04 * h9 + 4.9761369691e-05 * h10 + 3.2337349915e-05 * h11 + 1.3706418298e-04 * h12 + 1.6090722503e-04 * h13 + 1.7779831493e-04 * h14 + -2.8107855195e-05 * h15 + -2.7826050322e-04 * h16 + 1.0503471221e-05 * h17 + -6.5391750063e-05 * h18 + 1.3245215595e-04 * h19 + 1.6654208907e-04 * h20 + -2.5526288269e-04 * h21 + -5.0745038450e-05 * h22 + -1.3542951999e-04 * h23 + -2.8492627049e-04 * h24 + 2.3690808025e-04 * h25 + 8.8810267582e-05 * h26 + -7.8453023747e-05 * h27 + -1.1902861891e-04 * h28 + -3.9154063814e-05 * h29 + 1.2491667859e-04 * h30 + -1.0119194385e-04 * h31);
    k10 = tanh(5.2689804561e-02 + -2.1545802576e-01 * h0 + 6.6212143601e-02 * h1 + 8.5657537284e-02 * h2 + -4.9846489332e-02 * h3 + -1.3019612022e-01 * h4 + 6.0476248456e-02 * h5 + 8.4108641920e-02 * h6 + -6.2682058683e-03 * h7 + 8.9558449096e-02 * h8 + -2.3375102291e-02 * h9 + 2.1088561726e-02 * h10 + 9.5954299541e-02 * h11 + -8.9255662936e-02 * h12 + -1.8917772921e-02 * h13 + 5.8225747134e-02 * h14 + -3.0289835958e-02 * h15 + -1.1244668497e-01 * h16 + 4.9960111659e-02 * h17 + 6.0769492942e-02 * h18 + 2.6868298542e-02 * h19 + -2.9600911392e-02 * h20 + 1.6349088243e-01 * h21 + -1.4376798949e-02 * h22 + -1.6572361239e-02 * h23 + 5.9038066914e-02 * h24 + 7.3873975101e-02 * h25 + 4.7652856362e-02 * h26 + -8.8014832409e-03 * h27 + 8.7627724690e-04 * h28 + 4.7614214714e-02 * h29 + 1.3728531148e-01 * h30 + -8.9135289319e-02 * h31);
    k11 = tanh(-6.7518774790e-02 + 6.5127355772e-01 * h0 + -4.7296329931e-01 * h1 + -1.4075875249e-01 * h2 + 2.0306667577e-02 * h3 + -8.3638432884e-02 * h4 + 1.1475347133e-01 * h5 + 8.6551696405e-02 * h6 + 2.1428763826e-03 * h7 + 2.3557109167e-01 * h8 + -8.5133584466e-02 * h9 + 1.1686386043e-01 * h10 + -3.7152651989e-01 * h11 + 1.5287739263e-01 * h12 + 1.3788413101e-01 * h13 + -9.7379023150e-02 * h14 + 2.5330849132e-01 * h15 + 5.8881795108e-02 * h16 + 2.9119934545e-01 * h17 + 1.4009446482e-01 * h18 + -1.2485829250e-01 * h19 + 5.0298740672e-02 * h20 + 1.3845946219e-01 * h21 + 4.1316007903e-02 * h22 + -2.0830678596e-02 * h23 + -1.3198353636e-01 * h24 + 8.5487928055e-02 * h25 + 1.2531349740e-01 * h26 + -5.7922835211e-02 * h27 + -2.0982957089e-01 * h28 + 1.4946376730e-01 * h29 + 7.9645693854e-03 * h30 + -1.1058512191e-01 * h31);
    k12 = tanh(9.4718448541e-02 + -2.3264989013e-01 * h0 + -4.2231548401e-02 * h1 + 1.2517436250e-01 * h2 + 3.1725822398e-02 * h3 + -6.7044039375e-02 * h4 + 8.2166064816e-02 * h5 + -6.7748919665e-02 * h6 + -4.8590708713e-02 * h7 + 5.7770002008e-02 * h8 + -4.5244725650e-02 * h9 + 1.3759651263e-01 * h10 + 1.4181953116e-01 * h11 + 1.0213369690e-01 * h12 + -3.0538300994e-02 * h13 + 2.9720430223e-02 * h14 + -3.8008445927e-02 * h15 + -1.2962783753e-01 * h16 + 1.7180322157e-01 * h17 + 8.7931757943e-02 * h18 + -6.4434666394e-02 * h19 + 5.1422009962e-02 * h20 + 7.2217068331e-02 * h21 + -6.5269133983e-02 * h22 + -7.5277319053e-03 * h23 + 8.6471048922e-02 * h24 + 8.4504985371e-02 * h25 + 1.0523955813e-02 * h26 + 5.4483520753e-02 * h27 + -5.3487945123e-02 * h28 + -5.7140724360e-02 * h29 + -8.4070638158e-02 * h30 + -6.7334457513e-02 * h31);
    k13 = tanh(1.8256325640e-01 + -2.1586020972e-01 * h0 + -2.0311620205e-02 * h1 + 4.8977624668e-02 * h2 + -5.6140058380e-02 * h3 + -8.3447716242e-02 * h4 + -1.4356334982e-02 * h5 + -5.2192080529e-02 * h6 + 3.5378334044e-02 * h7 + -2.5990571070e-02 * h8 + 8.8747367138e-02 * h9 + 4.0056121972e-02 * h10 + 7.1198143490e-02 * h11 + -5.1522997415e-02 * h12 + -1.4057836012e-01 * h13 + 5.9246331806e-02 * h14 + 1.0546178552e-02 * h15 + 7.7721958387e-03 * h16 + 6.4419531155e-02 * h17 + 3.7625847311e-02 * h18 + -1.1860698565e-02 * h19 + 2.4155925650e-03 * h20 + 1.6886354033e-02 * h21 + -8.7635285372e-02 * h22 + 7.8484594750e-02 * h23 + 1.2858981869e-01 * h24 + 1.2623348263e-01 * h25 + -1.1536319473e-02 * h26 + -2.3463677264e-02 * h27 + -4.7584045464e-02 * h28 + -1.1314484473e-02 * h29 + 2.6668515171e-02 * h30 + 3.5906238966e-03 * h31);
    k14 = tanh(-6.5558373578e-02 + -2.6759746088e-01 * h0 + 2.1656244829e-01 * h1 + 6.9856983759e-02 * h2 + -1.4080657272e-01 * h3 + -3.9528951754e-02 * h4 + 3.0117897403e-02 * h5 + 7.6859595229e-02 * h6 + -1.3889551509e-01 * h7 + 1.8761159928e-01 * h8 + 1.7791085111e-02 * h9 + 5.4542710347e-02 * h10 + 6.5212745679e-02 * h11 + -1.1393230590e-01 * h12 + 1.8480323014e-02 * h13 + 1.2437376510e-01 * h14 + 7.7919032050e-02 * h15 + -2.2916042663e-02 * h16 + -9.9061888373e-03 * h17 + 1.6493956757e-02 * h18 + 1.3742281567e-01 * h19 + 8.8050960701e-02 * h20 + -9.0464389998e-02 * h21 + -1.4449076143e-01 * h22 + -7.7336138137e-02 * h23 + 1.1519809821e-01 * h24 + 2.0319228100e-01 * h25 + 1.6802480104e-01 * h26 + -1.4708355977e-01 * h27 + -6.2415759371e-02 * h28 + 1.0218868580e-02 * h29 + -9.1345390298e-03 * h30 + -6.4365962678e-02 * h31);
    k15 = tanh(1.6691177212e-01 + -2.7482134080e-01 * h0 + 1.7751495625e-02 * h1 + 8.5460180278e-02 * h2 + -5.0883258525e-02 * h3 + 2.3607196289e-02 * h4 + -3.5754322908e-02 * h5 + -6.0220774253e-02 * h6 + -9.1347328547e-02 * h7 + -2.3455120503e-02 * h8 + 4.7547200297e-02 * h9 + 4.0991418739e-02 * h10 + 5.5073392569e-02 * h11 + -2.1686078760e-02 * h12 + -5.4269460732e-02 * h13 + 8.0028863053e-02 * h14 + -1.2050659781e-01 * h15 + -1.0635028202e-01 * h16 + 4.6483483302e-02 * h17 + 5.0402853657e-02 * h18 + 3.5234692718e-02 * h19 + -1.2734399818e-02 * h20 + 9.2166157420e-02 * h21 + -9.5061969255e-03 * h22 + -4.8697934885e-02 * h23 + 7.6642930155e-02 * h24 + 5.5646936611e-02 * h25 + 1.3922794976e-02 * h26 + 2.9024523359e-02 * h27 + -6.3827475275e-02 * h28 + 6.1872854769e-02 * h29 + 3.9058587765e-02 * h30 + 4.3713508042e-03 * h31);
    k16 = tanh(-8.0477725167e-02 + 6.1676836003e-02 * h0 + -1.7065561713e-02 * h1 + -3.0013586965e-02 * h2 + 6.7337383054e-03 * h3 + 6.2913259506e-02 * h4 + -2.2990175586e-02 * h5 + 5.5244072150e-02 * h6 + 3.5145670946e-02 * h7 + -1.0118967889e-02 * h8 + 4.5821820108e-02 * h9 + -2.5788231976e-02 * h10 + -4.6843626500e-02 * h11 + -3.2141462064e-02 * h12 + -4.4580775254e-04 * h13 + 1.4226870748e-02 * h14 + 6.6727151926e-02 * h15 + 1.1945170606e-01 * h16 + -9.8961002360e-02 * h17 + -4.0502824491e-02 * h18 + 6.8692322679e-03 * h19 + 6.8679605780e-03 * h20 + -1.1359791434e-01 * h21 + 5.0881667408e-03 * h22 + 4.3973296589e-03 * h23 + -7.6177004137e-02 * h24 + 1.4989663096e-02 * h25 + -6.4890053079e-03 * h26 + 2.6766127742e-02 * h27 + 8.5672098709e-02 * h28 + 1.7853035033e-02 * h29 + -5.8907538476e-02 * h30 + -6.6792128356e-03 * h31);
    k17 = tanh(-8.2750161011e-02 + 1.5719319958e-01 * h0 + -3.2206875351e-02 * h1 + -9.5150736601e-03 * h2 + 4.0030219477e-02 * h3 + 8.7216855612e-02 * h4 + 4.0876273115e-03 * h5 + -1.5309393169e-02 * h6 + 3.6105307351e-02 * h7 + -3.1926273321e-02 * h8 + -2.5474299029e-02 * h9 + -3.4042098712e-02 * h10 + -2.3459173381e-02 * h11 + -3.0258607107e-02 * h12 + -6.9809837536e-03 * h13 + 3.6537098757e-02 * h14 + 7.2500803630e-02 * h15 + -6.3180812598e-02 * h16 + -1.0713680295e-01 * h17 + -3.0430546120e-02 * h18 + -3.0710190617e-02 * h19 + 4.7987890244e-02 * h20 + 5.2668311147e-02 * h21 + 3.0115029330e-02 * h22 + 1.0352818780e-02 * h23 + -1.1859725744e-01 * h24 + -2.0494557966e-02 * h25 + -8.6743935605e-03 * h26 + 3.0926158890e-02 * h27 + 1.0800271972e-01 * h28 + 1.9237092605e-02 * h29 + -8.6043904516e-02 * h30 + 1.0486366582e-02 * h31);
    k18 = tanh(4.7330729978e-02 + 1.0511947409e-01 * h0 + 1.3311357736e-02 * h1 + -1.1878316758e-01 * h2 + 4.7403284509e-02 * h3 + 1.2422821306e-02 * h4 + 5.0208263518e-03 * h5 + -7.9947242259e-02 * h6 + -4.1227066324e-02 * h7 + -1.8347158445e-02 * h8 + 6.5041411625e-03 * h9 + -1.1186852738e-01 * h10 + -1.2936276432e-01 * h11 + 3.4970144074e-02 * h12 + 1.6750183379e-01 * h13 + -2.8461466986e-02 * h14 + 1.2867696167e-01 * h15 + 7.6555090588e-02 * h16 + -3.8235273658e-02 * h17 + -3.0408375654e-02 * h18 + -1.9039433874e-02 * h19 + 3.2567303167e-03 * h20 + -8.4712690062e-02 * h21 + 3.4717629896e-02 * h22 + 5.0825682085e-02 * h23 + -8.1090953904e-02 * h24 + -1.2847213555e-01 * h25 + -6.4415849197e-02 * h26 + -4.4072987952e-02 * h27 + -3.9918805467e-02 * h28 + 2.9669678144e-02 * h29 + 7.4403939983e-02 * h30 + 6.3432652211e-02 * h31);
    k19 = tanh(3.1536536988e-02 + -2.7743850566e-01 * h0 + 2.7717171999e-02 * h1 + -4.8674762981e-02 * h2 + -2.5227210024e-02 * h3 + -3.8591205085e-02 * h4 + -1.5578906062e-01 * h5 + 1.1787550949e-01 * h6 + 1.4362176956e-02 * h7 + 9.4459152329e-02 * h8 + 4.5302672316e-02 * h9 + 5.9943730224e-02 * h10 + 2.0297900797e-01 * h11 + -8.7808905143e-03 * h12 + -2.0662989738e-01 * h13 + 6.4685989225e-02 * h14 + -1.1950142245e-01 * h15 + -1.2692161557e-01 * h16 + 2.6259538716e-02 * h17 + 1.2764737914e-01 * h18 + -8.9755042808e-02 * h19 + -9.0899590658e-02 * h20 + 9.8036329066e-02 * h21 + -2.1330299082e-02 * h22 + 4.7241659130e-02 * h23 + 1.3895434839e-01 * h24 + 1.3059656707e-01 * h25 + 6.6551020567e-02 * h26 + -1.1497611039e-02 * h27 + -5.4973692087e-02 * h28 + 3.1007049366e-02 * h29 + -2.6885888311e-02 * h30 + 7.2001586778e-02 * h31);
    k20 = tanh(-3.0218376590e-02 + -6.1811808785e-05 * h0 + 3.2518625716e-03 * h1 + 4.2324923499e-04 * h2 + -2.7777915513e-05 * h3 + 6.2574721501e-03 * h4 + -1.3496336157e-03 * h5 + 1.1066193628e-02 * h6 + -2.4964835308e-03 * h7 + -1.3098154407e-03 * h8 + -1.7265438175e-03 * h9 + -9.4078147689e-04 * h10 + -5.7131266369e-04 * h11 + -2.2646252912e-03 * h12 + -2.4085365812e-03 * h13 + -4.2294241786e-03 * h14 + 5.7745337748e-04 * h15 + -5.3281266382e-03 * h16 + -2.2552754901e-04 * h17 + 1.0831192028e-03 * h18 + -2.3478483266e-03 * h19 + -2.7853099195e-03 * h20 + 4.9731016687e-03 * h21 + 9.5709864142e-04 * h22 + 2.0586415508e-03 * h23 + -1.8978191619e-03 * h24 + -8.6322475031e-03 * h25 + -1.5597472184e-03 * h26 + 1.8631811151e-03 * h27 + 7.7107645634e-03 * h28 + 6.8628172125e-04 * h29 + -8.8365129007e-04 * h30 + 1.7473465241e-03 * h31);
    k21 = tanh(-1.4407948127e-01 + 3.8081287171e-01 * h0 + 2.8642635360e-02 * h1 + -1.6977107031e-02 * h2 + 6.5025838353e-02 * h3 + 1.4182808529e-01 * h4 + -4.2354163992e-02 * h5 + -1.1155091482e-01 * h6 + 1.1131963869e-01 * h7 + -9.0983054175e-02 * h8 + 3.6699055906e-03 * h9 + -8.7339666221e-02 * h10 + -1.4811790979e-01 * h11 + -1.1551539758e-01 * h12 + -6.6248865031e-02 * h13 + -5.8771782320e-02 * h14 + 1.0440651540e-01 * h15 + 4.6544906921e-02 * h16 + -2.3611824791e-01 * h17 + 1.6111065025e-02 * h18 + -4.4116585395e-02 * h19 + -2.5391864463e-02 * h20 + -6.5446935370e-02 * h21 + 9.7037061568e-02 * h22 + -5.8623949089e-03 * h23 + -1.4589635418e-01 * h24 + -1.3347897444e-01 * h25 + -3.2327134270e-02 * h26 + 2.1884517242e-02 * h27 + -5.3378151037e-02 * h28 + 3.6792184300e-02 * h29 + 4.9483702069e-02 * h30 + 1.5067106469e-01 * h31);
    k22 = tanh(-7.2073172508e-02 + 2.5518191413e-01 * h0 + 2.3070062089e-02 * h1 + -3.8675743535e-02 * h2 + 7.0442387353e-02 * h3 + 1.2550492402e-01 * h4 + 1.7470343055e-02 * h5 + -5.8669016628e-02 * h6 + -2.5972576309e-02 * h7 + -9.3661590823e-02 * h8 + -1.1665372467e-01 * h9 + -6.9213556199e-02 * h10 + -1.3219298349e-01 * h11 + 3.1545658329e-02 * h12 + 1.5475245717e-01 * h13 + -6.0074954480e-02 * h14 + 1.0474758131e-01 * h15 + 1.5148711856e-02 * h16 + -8.9334996118e-02 * h17 + -1.3004439849e-02 * h18 + -9.0085186151e-02 * h19 + 7.7312571121e-02 * h20 + -5.7493482447e-02 * h21 + 2.2605671411e-02 * h22 + -3.0077140247e-02 * h23 + -1.0560592345e-01 * h24 + -1.0686150797e-02 * h25 + 1.1894091487e-02 * h26 + 4.9431400098e-02 * h27 + -1.3783921646e-02 * h28 + -1.0120696905e-02 * h29 + -9.7318787109e-02 * h30 + 9.1896752228e-02 * h31);
    k23 = tanh(1.2532416127e-01 + -1.8643663567e-01 * h0 + -2.5003032279e-02 * h1 + -2.1493361127e-03 * h2 + -2.4893121537e-02 * h3 + -1.8580079401e-02 * h4 + -9.4549169184e-02 * h5 + -1.1159257466e-01 * h6 + -1.5613338824e-02 * h7 + 3.1822960614e-02 * h8 + 7.8260166122e-02 * h9 + 8.1439101664e-03 * h10 + -5.2222086460e-02 * h11 + -7.8528656013e-02 * h12 + -1.5577756964e-01 * h13 + 1.0355755184e-01 * h14 + -1.2069870209e-01 * h15 + 1.0955811342e-01 * h16 + -3.1308916864e-02 * h17 + 2.0803843645e-01 * h18 + 1.4560295607e-02 * h19 + -1.2131710121e-01 * h20 + 1.7545803107e-01 * h21 + 3.4107907005e-02 * h22 + 4.3188433266e-02 * h23 + 1.8875014675e-01 * h24 + 5.5298791345e-02 * h25 + -4.6043598281e-02 * h26 + 4.4669368818e-02 * h27 + 4.9025545969e-02 * h28 + 1.0982725667e-01 * h29 + 9.0518110691e-02 * h30 + 8.6193376446e-02 * h31);
    k24 = tanh(1.0933994238e-01 + -1.3209745866e-01 * h0 + 3.2267952358e-02 * h1 + 6.3659149109e-02 * h2 + -2.3997341066e-02 * h3 + -1.1963560139e-02 * h4 + 1.8266621320e-02 * h5 + 6.8402769389e-02 * h6 + -9.5504265712e-02 * h7 + 1.0112836630e-02 * h8 + 3.7949514539e-02 * h9 + 5.7676743451e-02 * h10 + 6.9094177704e-02 * h11 + 3.4994538707e-02 * h12 + -8.8549804979e-02 * h13 + 5.3523698897e-02 * h14 + -3.0827912606e-02 * h15 + -1.1521887967e-01 * h16 + 8.2039695132e-02 * h17 + 2.4223595413e-02 * h18 + 1.4793242734e-02 * h19 + -9.7457623786e-03 * h20 + -1.0021766178e-02 * h21 + -1.5678304122e-02 * h22 + 3.9438153253e-02 * h23 + 7.2351512774e-02 * h24 + -3.0986096995e-02 * h25 + 6.5485459472e-03 * h26 + -1.3853833780e-02 * h27 + -9.0409002141e-02 * h28 + -1.1091544340e-02 * h29 + 5.0798356885e-02 * h30 + -5.7072110249e-02 * h31);
    k25 = tanh(-9.9133759592e-02 + 3.0614331571e-01 * h0 + 1.1539751535e-01 * h1 + -5.9912935141e-03 * h2 + 2.4075979305e-02 * h3 + -7.7427118678e-02 * h4 + 1.8320358535e-01 * h5 + 4.6834790065e-02 * h6 + 1.8653838811e-01 * h7 + -5.3118241565e-02 * h8 + -1.1479870856e-01 * h9 + -3.9617074398e-01 * h10 + 5.1667473075e-02 * h11 + -3.7978122444e-02 * h12 + 5.1268136477e-03 * h13 + -1.5717445900e-01 * h14 + 1.2052829576e-01 * h15 + -8.9259136013e-02 * h16 + 1.5804413255e-01 * h17 + -3.1561912658e-03 * h18 + -5.7139723210e-02 * h19 + 1.5345603075e-01 * h20 + -1.1061824069e-01 * h21 + 1.0248812112e-01 * h22 + 3.8431569923e-02 * h23 + -9.7659077924e-03 * h24 + -1.2363711673e-01 * h25 + -7.5097246114e-02 * h26 + -8.1893393258e-02 * h27 + 1.3033237162e-01 * h28 + -1.3623637002e-01 * h29 + -1.0340564893e-01 * h30 + 8.3647824229e-02 * h31);
    k26 = tanh(-2.8742793967e-01 + 5.0689747154e-03 * h0 + -3.2791406630e-01 * h1 + 2.8374580959e-01 * h2 + -2.4692512235e-02 * h3 + -4.8840220430e-01 * h4 + 3.2776020989e-01 * h5 + -3.5878416578e-01 * h6 + 1.0890235793e-01 * h7 + 7.5979352524e-01 * h8 + -2.9201611640e-01 * h9 + -6.9024372874e-01 * h10 + 3.4386899664e-01 * h11 + -1.1260750302e-01 * h12 + 1.4614528337e-02 * h13 + 6.3844575277e-01 * h14 + -1.1139922821e-01 * h15 + -7.9574314623e-01 * h16 + 4.2508565777e-01 * h17 + -2.0669514095e-01 * h18 + 5.4474645539e-01 * h19 + 9.2700787202e-02 * h20 + -4.8605619411e-01 * h21 + -1.4367016808e-01 * h22 + -1.2165552191e-01 * h23 + 2.4382586146e-02 * h24 + 3.2857473779e-01 * h25 + 2.8634424729e-01 * h26 + -7.6413946427e-01 * h27 + 1.7687991557e-02 * h28 + -5.0715944855e-01 * h29 + 3.6434977432e-01 * h30 + -1.1209878617e-01 * h31);
    k27 = tanh(1.8964140583e-01 + -1.6885383106e-01 * h0 + 1.2487841704e-02 * h1 + 1.1039349980e-01 * h2 + -3.6829592457e-02 * h3 + 4.9499721402e-03 * h4 + 4.3172125198e-02 * h5 + -4.7354486497e-02 * h6 + 2.9896964448e-02 * h7 + 8.2802518817e-02 * h8 + -1.6335780901e-02 * h9 + 5.9347868902e-02 * h10 + 9.1042126486e-02 * h11 + 8.0577218085e-02 * h12 + 2.7634740935e-02 * h13 + 4.3023698094e-02 * h14 + -2.2243320945e-03 * h15 + -1.9564997714e-02 * h16 + 1.2648529600e-01 * h17 + 8.7829091648e-02 * h18 + 2.0966856714e-03 * h19 + -7.5676371469e-02 * h20 + -4.9847766595e-02 * h21 + 2.5799784638e-03 * h22 + 4.0072742136e-03 * h23 + 1.6090794965e-01 * h24 + 1.0734469157e-01 * h25 + 8.2636329332e-03 * h26 + -4.3679084474e-02 * h27 + -1.3479834878e-01 * h28 + -2.9171406288e-02 * h29 + 6.1216126068e-02 * h30 + -1.4797762295e-02 * h31);
    k28 = tanh(-1.2960889152e-01 + 6.2284647462e-02 * h0 + 3.7891740854e-02 * h1 + -6.1239024587e-02 * h2 + 1.8280754659e-02 * h3 + -2.2097841431e-02 * h4 + -1.7424870058e-02 * h5 + 2.1294717597e-02 * h6 + -6.4717002861e-02 * h7 + -3.3338212966e-02 * h8 + 1.5350845131e-02 * h9 + -5.4256509247e-02 * h10 + -7.2431832362e-02 * h11 + 3.1396765261e-02 * h12 + -7.1349920371e-02 * h13 + -7.5158528883e-02 * h14 + 7.9787437966e-02 * h15 + -2.7916528991e-02 * h16 + -9.7552787089e-02 * h17 + -2.9955775272e-03 * h18 + -1.0568720580e-02 * h19 + 4.7258123500e-02 * h20 + -8.0505273721e-02 * h21 + 3.7093729489e-02 * h22 + -5.6404834166e-02 * h23 + -1.2865891517e-01 * h24 + -1.1040968815e-01 * h25 + 1.3131670996e-02 * h26 + 1.1422361801e-02 * h27 + 3.9750279952e-02 * h28 + 1.8200306619e-02 * h29 + -1.0981089064e-01 * h30 + 3.0353774427e-02 * h31);
    k29 = tanh(-1.7743444050e-01 + -8.3326336194e-02 * h0 + -9.5982673351e-01 * h1 + -2.5942560962e-01 * h2 + -1.5718517376e-01 * h3 + -2.7479812291e-01 * h4 + -1.6391039109e-01 * h5 + -2.5360770375e-01 * h6 + -1.7812137595e-01 * h7 + 6.5025948449e-01 * h8 + 2.7509575158e-01 * h9 + -4.9735819908e-01 * h10 + -2.7564101795e-01 * h11 + 1.8013496597e-02 * h12 + -2.3497441037e-01 * h13 + 3.7029545538e-01 * h14 + -3.9930268831e-01 * h15 + -3.5979981324e-01 * h16 + -2.9427824099e-02 * h17 + -2.7804934086e-01 * h18 + 2.3887298415e-01 * h19 + -4.3331510673e-02 * h20 + -1.1504712686e-01 * h21 + -2.3687759061e-01 * h22 + -7.5766015297e-02 * h23 + -8.5552090019e-02 * h24 + 4.2637787663e-01 * h25 + 3.7853017856e-01 * h26 + -2.8827126329e-02 * h27 + -4.4586783792e-01 * h28 + -3.1563758290e-02 * h29 + 2.3938217452e-01 * h30 + -1.0254019698e-01 * h31);
    k30 = tanh(1.8424672088e-01 + -2.5043548485e-02 * h0 + -4.8981819994e-01 * h1 + 9.4908626354e-02 * h2 + 1.7009933515e-01 * h3 + -2.2198340916e-01 * h4 + 8.0609078291e-02 * h5 + -2.1922916758e-01 * h6 + 2.1639210904e-02 * h7 + 1.8681311070e-01 * h8 + 1.0435358564e-01 * h9 + -2.7681914403e-01 * h10 + 2.5606989401e-01 * h11 + -6.0511967607e-02 * h12 + 1.5105585667e-02 * h13 + 5.2910935189e-02 * h14 + -1.6037065419e-01 * h15 + -1.6844096697e-01 * h16 + -1.4816839323e-02 * h17 + 5.2945807863e-01 * h18 + 1.5086794409e-01 * h19 + 4.3686970955e-02 * h20 + -9.3715818158e-02 * h21 + 7.1097727099e-02 * h22 + 9.3967642895e-02 * h23 + -7.1334576648e-02 * h24 + 1.2470544621e-01 * h25 + 1.3152430573e-01 * h26 + -1.4598758368e-01 * h27 + 1.2067543658e-01 * h28 + -3.4585126439e-01 * h29 + 7.4625536226e-02 * h30 + -1.4598238333e-01 * h31);
    k31 = tanh(-1.1245713228e-01 + -5.3091830538e-02 * h0 + 2.7658719469e-03 * h1 + 3.3001430299e-02 * h2 + -1.5844166904e-02 * h3 + -6.6355060142e-02 * h4 + -8.0458347412e-03 * h5 + -5.2942638788e-02 * h6 + -3.3891124821e-02 * h7 + 6.2194546322e-03 * h8 + 1.4963935916e-02 * h9 + 1.9027656792e-02 * h10 + 1.4631130032e-02 * h11 + -5.4391764286e-02 * h12 + -8.9296962883e-02 * h13 + -3.8176180739e-02 * h14 + -6.6624765510e-02 * h15 + 1.7898895046e-02 * h16 + 3.5699434651e-02 * h17 + 1.4748436189e-02 * h18 + 1.7168758676e-02 * h19 + 1.0025157652e-02 * h20 + 9.2572889272e-02 * h21 + -2.2612978223e-02 * h22 + 2.4953392790e-02 * h23 + 1.1471168612e-01 * h24 + 2.3835092264e-02 * h25 + -9.2304449269e-03 * h26 + 2.1678194879e-02 * h27 + -2.5377668184e-02 * h28 + 3.8160951891e-03 * h29 + 6.9418055733e-02 * h30 + -1.6998656043e-02 * h31);
    acc = -4.0403883931e-02 + 4.3114721886e-03 * k0 + 6.5285886334e-02 * k1 + 5.8765554830e-02 * k2 + -4.4255890905e-02 * k3 + 6.7395932343e-02 * k4 + -1.4982070618e-01 * k5 + -3.4932807774e-01 * k6 + 3.7102457064e-02 * k7 + -1.7226572927e-01 * k8 + -6.3599648879e-08 * k9 + -1.9451094820e-01 * k10 + 2.8478726586e-01 * k11 + -1.0333419126e-01 * k12 + -9.5588477656e-02 * k13 + -1.1052630132e-01 * k14 + -1.2391498854e-01 * k15 + 6.1920011989e-02 * k16 + 7.0571949938e-02 * k17 + 6.6904205147e-02 * k18 + -2.0593600526e-01 * k19 + 1.8048970698e-05 * k20 + 2.8227867768e-01 * k21 + 1.7535626847e-01 * k22 + -8.1351218469e-02 * k23 + -6.8896059662e-02 * k24 + 3.1966410349e-01 * k25 + -3.0863090671e-01 * k26 + -1.1661078342e-01 * k27 + 5.3541924654e-02 * k28 + -1.7308567554e-01 * k29 + -2.0516838729e-01 * k30 + -1.6181498695e-02 * k31;
    gsum = gsum + 1 * tanh(acc);
    I(d, s) <+ (exp(gsum / 5) - 1.0) * ib;
  end
endmodule

// Netlist use (one transistor):
//   M1 di g s b <bsim4 card> L=.. W=..
//   YCORR d g s di e1_corr L=.. W=.. pmos=..
