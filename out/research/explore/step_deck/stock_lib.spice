* stock SkyWater sky130A tt corner; the section name tt_77k is only the name the
* simulate_pdk deck asks for. tnom and temperature coefficients are the stock ones.
.lib tt_77k
.lib "/Users/anrunw/Documents/cryo-ml/data/raw/pdk/sky130A/libs.tech/ngspice/sky130.lib.spice" tt
.endl
