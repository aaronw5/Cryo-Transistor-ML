`include "disciplines.vams"
`include "constants.vams"
// I12-1 bias-only correction g v2 (M_bias_v2), 1-member 3-16-...-1 tanh MLP ensemble.
// I(d->s) added = (exp(g) - 1) * I(sense); I(sense) = drain current of a
// charge-free replica of the card (static), so the element has no charge.
// Inputs (d/s symmetric): sg = 1 - 2 is_pmos, a = sg V(g,s), b = sg V(g,d),
// m = sqrt(V(d,s)^2 + EPS^2), x1 = (a + b + m) / (2 VDD), x2 = m / VDD,
// EPS = 0.01 V, VDD = 1.85 V.
module i12_1_bias_corr_v2(d, g, s, rx, ri);
  inout d, g, s, rx, ri;
  electrical d, g, s, rx, ri;
  branch (rx, ri) sense;   // I(sense) = replica drain current
  parameter real is_pmos = 0;  // 0 nMOS, 1 pMOS
  parameter real RS = 0.0;   // ohm; sense branch V = RS * I (0: zero-volt source)
  real ib, gsum, acc, sg, vgs, vgd, vds, mm, x0, x1, x2;
  real h0, h1, h2, h3, h4, h5, h6, h7, h8, h9, h10, h11, h12, h13, h14, h15;
  real k0, k1, k2, k3, k4, k5, k6, k7, k8, k9, k10, k11, k12, k13, k14, k15;
  analog begin
    V(sense) <+ RS * I(sense);
    ib = I(sense);
    sg = 1.0 - 2.0 * is_pmos;
    vgs = V(g, s);
    vgd = V(g, d);
    vds = V(d, s);
    mm = sqrt(vds * vds + 1.00000000000000005e-04);
    x0 = (is_pmos - 0.00000000000000000e+00) / 1.00000000000000000e+00;
    x1 = ((sg * vgs + sg * vgd + mm) / 3.70000000000000018e+00 - 6.90127958147829568e-01) / 2.25142936721873244e-01;
    x2 = (mm / 1.85000000000000009e+00 - 5.08329074361641875e-01) / 3.18204328233310130e-01;
    gsum = 0.0;
    // ensemble member 0
    h0 = tanh(-6.75130674283736854e-01 + 2.37075202477605787e-02 * x0 + 1.25589560262085786e-01 * x1 + -6.40575019933394163e-01 * x2);
    h1 = tanh(1.04340887639077562e-01 + -2.58030358756735689e-01 * x0 + -8.82945681929591802e-02 * x1 + 9.71707896031238222e-02 * x2);
    h2 = tanh(4.10515276537534501e-01 + -5.42483721342767317e-02 * x0 + 5.91007611864203475e-01 * x1 + 1.46915022769414233e-01 * x2);
    h3 = tanh(5.87261776846865979e-01 + 4.65747389446560245e-02 * x0 + -3.00339142650764057e-01 * x1 + -1.45382259220110777e-01 * x2);
    h4 = tanh(3.47755139649137471e-02 + -5.18703291484829965e-01 * x0 + -2.55806686850466869e-01 * x1 + -2.30178701903618388e-01 * x2);
    h5 = tanh(9.50622461987347539e-02 + -1.14166852293415638e-01 * x0 + 1.58289399144805693e-01 * x1 + 2.14502339355980925e-01 * x2);
    h6 = tanh(5.37644240729311385e-01 + -3.28563960733959048e-01 * x0 + -1.27029568682679811e-01 * x1 + 2.26636894660133509e-01 * x2);
    h7 = tanh(-1.22872664032505602e-01 + 4.06213186675942250e-01 * x0 + 1.44209234262136471e-01 * x1 + 6.41385071171854171e-01 * x2);
    h8 = tanh(1.05105467732452690e-01 + -1.75421919801614284e-01 * x0 + 6.04118243614991182e-02 * x1 + 7.87595900133001625e-01 * x2);
    h9 = tanh(-3.19842639343909274e-01 + -3.49344224485714061e-01 * x0 + -1.04175220042481323e-01 * x1 + -1.36835505419661219e-01 * x2);
    h10 = tanh(-5.22213084211706091e-01 + -7.43737306464284653e-02 * x0 + 5.05996526761072984e-01 * x1 + -3.26747753846470590e-01 * x2);
    h11 = tanh(-6.12130485260922064e-01 + -1.70498032130635413e-01 * x0 + -4.56154402698560557e-01 * x1 + -1.03865523997035436e+00 * x2);
    h12 = tanh(1.83935387417740598e-01 + -2.73154503221053668e-01 * x0 + 2.90302255073706716e-01 * x1 + 3.12308930225806192e-01 * x2);
    h13 = tanh(2.49189521254060575e-01 + 4.45640863813704047e-01 * x0 + 8.75684734683703503e-02 * x1 + -4.03245420386756426e-01 * x2);
    h14 = tanh(-5.67406768389848826e-01 + 2.46103718702305602e-01 * x0 + -3.41534517599866860e-01 * x1 + -5.55904315716679309e-01 * x2);
    h15 = tanh(2.24381800727882885e-01 + -2.87683704744201851e-01 * x0 + 2.76718315659509995e-01 * x1 + 3.01956007817025140e-01 * x2);
    k0 = tanh(5.04579721894395025e-02 + 1.36741958956620502e-01 * h0 + -9.91219306129214467e-02 * h1 + 6.48236263262289142e-02 * h2 + 1.13801025055188701e-01 * h3 + 6.15545239863463170e-02 * h4 + 1.17683663297646748e-01 * h5 + -2.09773077559660598e-01 * h6 + -9.63388864371095416e-02 * h7 + 1.39642309299679357e-01 * h8 + 9.55209263165147648e-02 * h9 + 2.36262498127128351e-01 * h10 + 2.40965931942210443e-01 * h11 + -1.88229806178516687e-02 * h12 + -2.57835948952863714e-01 * h13 + 7.24838520051337143e-02 * h14 + -1.76689382868484096e-01 * h15);
    k1 = tanh(5.02234511323275470e-02 + -8.65168675216814592e-02 * h0 + -4.22154868134404712e-02 * h1 + 1.57338848789414648e-01 * h2 + -2.95592917290385983e-02 * h3 + 3.22492525524122470e-02 * h4 + -6.99173341783458774e-02 * h5 + -8.92603814594428169e-02 * h6 + -1.20662139503997790e-01 * h7 + 7.53419683384208422e-02 * h8 + -1.33903193795867376e-01 * h9 + 1.16948447177167306e-01 * h10 + 1.32910835889009232e-01 * h11 + 5.48952233565891748e-02 * h12 + -6.88340878566885001e-02 * h13 + -1.27155189130673307e-01 * h14 + -1.56416434595009868e-01 * h15);
    k2 = tanh(-2.14438918908196968e-01 + 1.13015459025699191e-01 * h0 + 5.19264360544195794e-02 * h1 + -2.13525342148871144e-01 * h2 + -2.03216350916935767e-01 * h3 + 2.21942073581766430e-01 * h4 + 1.66598001809066698e-01 * h5 + -3.53609124697468399e-02 * h6 + -5.21199301593269493e-02 * h7 + -3.18427116173117364e-01 * h8 + 4.43466090306614269e-02 * h9 + -1.95104556009507574e-01 * h10 + -1.97866796562406716e-01 * h11 + 2.78640090164267162e-02 * h12 + 2.67511777788288330e-01 * h13 + -1.16955126465659920e-01 * h14 + 1.73562228122147721e-01 * h15);
    k3 = tanh(7.17799954117363109e-02 + -7.23405953811696451e-02 * h0 + -1.62613813660567388e-02 * h1 + 2.12117698096174950e-01 * h2 + -3.56550730995059129e-02 * h3 + -7.67574953836218099e-02 * h4 + -1.63924267827628874e-02 * h5 + -7.26862142623577040e-02 * h6 + -3.01275556784111574e-02 * h7 + 1.23640820024376041e-01 * h8 + -6.18806690583960650e-02 * h9 + -7.01092469961615665e-03 * h10 + 1.20923095112748305e-01 * h11 + -2.14341512225989156e-01 * h12 + -1.30835895643705402e-01 * h13 + -3.29900740008330987e-02 * h14 + -1.29318378551920132e-01 * h15);
    k4 = tanh(1.80735347955931436e-01 + -6.05994313007241561e-02 * h0 + -9.22924404450779640e-02 * h1 + -2.13749010522575437e-02 * h2 + 9.69348297830622402e-02 * h3 + -1.03152118235539561e-01 * h4 + -3.84694194552451171e-02 * h5 + 8.24763594793179317e-02 * h6 + -4.80445666553557249e-02 * h7 + 7.24468903022584682e-02 * h8 + -3.27815452831274959e-02 * h9 + 7.53973122202140356e-02 * h10 + 1.71899019912991669e-01 * h11 + 1.58643517484943708e-01 * h12 + -6.87055584168920347e-02 * h13 + 2.34400885849640667e-01 * h14 + -4.99595696228245165e-02 * h15);
    k5 = tanh(2.27598034558643858e-01 + -8.27668625921159778e-02 * h0 + -8.68015615766819237e-02 * h1 + 1.16737738611397329e-01 * h2 + 6.20844063684288308e-02 * h3 + -5.88514853249390846e-02 * h4 + -1.17215284158353833e-01 * h5 + -1.17816011048117272e-01 * h6 + -1.06360405341623387e-01 * h7 + -1.76181344581203755e-02 * h8 + 6.27858822875188155e-02 * h9 + 9.29859231367120148e-02 * h10 + -1.16953442147946104e-01 * h11 + 4.34178950523701826e-02 * h12 + -7.30724314482251586e-02 * h13 + 4.40237685142299238e-03 * h14 + -8.88804467780493906e-02 * h15);
    k6 = tanh(8.71624791599771853e-02 + -8.31286594529783290e-02 * h0 + 4.12991865158476509e-02 * h1 + -2.60252249472605668e-01 * h2 + -2.93916908726525428e-01 * h3 + -2.52663335860415159e-02 * h4 + 4.15936178652578509e-02 * h5 + 2.36492902315069871e-02 * h6 + 1.48240029524739747e-01 * h7 + -2.40495201647558526e-01 * h8 + 5.64575217420060296e-02 * h9 + 8.28791859027651900e-02 * h10 + -1.34206837455000172e-01 * h11 + 2.18630355718592018e-01 * h12 + 2.13489842625991716e-01 * h13 + -2.29062408154013381e-01 * h14 + 1.81150245045117148e-01 * h15);
    k7 = tanh(6.68437560682961784e-02 + 1.08460620402515851e-02 * h0 + -1.83649136485649095e-01 * h1 + 2.01519838154102876e-01 * h2 + -3.04449354382651492e-02 * h3 + -1.60302375544494453e-04 * h4 + -6.57879090975395514e-02 * h5 + 1.68055999273367083e-02 * h6 + -2.65196505296403373e-02 * h7 + 1.15469759288071724e-01 * h8 + 1.66062553449489378e-02 * h9 + 1.91806254414049020e-02 * h10 + -4.74514572946929322e-03 * h11 + -1.84934558598374627e-01 * h12 + -4.56665362550347093e-02 * h13 + 1.86375308045154481e-01 * h14 + 8.20414633972995355e-02 * h15);
    k8 = tanh(1.07525118130691461e-01 + -1.52232333903894596e-01 * h0 + 7.74954355530410033e-02 * h1 + -1.91016150114474231e-01 * h2 + -1.68132587139178197e-01 * h3 + -8.63579891755651557e-02 * h4 + 1.00572175938792724e-01 * h5 + 1.00129690744248066e-02 * h6 + 6.06291397503707329e-03 * h7 + -1.00427566453647435e-01 * h8 + 1.83447146099676189e-01 * h9 + -2.32723237397530591e-01 * h10 + -2.03630713324716578e-01 * h11 + -6.77797090905673666e-02 * h12 + 3.32229350399569301e-01 * h13 + -1.25326717448762476e-01 * h14 + 2.29655549937007680e-01 * h15);
    k9 = tanh(-1.34549907556403697e-01 + 2.72900855151134297e-02 * h0 + 9.73101546721213129e-02 * h1 + -2.92322248938193946e-02 * h2 + -7.89318264050754559e-02 * h3 + 2.96508901877004585e-02 * h4 + -2.83484963490175526e-03 * h5 + 7.88142186821998159e-02 * h6 + 5.85508640445587744e-02 * h7 + -1.49647107718465899e-01 * h8 + -6.58447373821935550e-02 * h9 + 6.27578923911893127e-02 * h10 + -1.95450511673583655e-01 * h11 + 2.34327682647158253e-02 * h12 + 8.97224119562133188e-02 * h13 + 3.71006660103141150e-02 * h14 + 4.13982429440879693e-02 * h15);
    k10 = tanh(-5.09939092958313842e-02 + -5.27128374170082847e-01 * h0 + 3.21338020296598303e-01 * h1 + -9.20079188692233679e-02 * h2 + 5.93839618782946235e-02 * h3 + -6.95908510949373171e-02 * h4 + 1.64912993988505729e-01 * h5 + 3.69629551792311217e-01 * h6 + 3.80621621898133866e-01 * h7 + 2.71525586680277931e-01 * h8 + 1.11937618138549036e-01 * h9 + -1.43549223466938464e-01 * h10 + -3.57928103482015758e-01 * h11 + 3.08755209922313589e-01 * h12 + -1.70157878792821654e-01 * h13 + -3.38900216569522128e-01 * h14 + 2.98540664589834470e-01 * h15);
    k11 = tanh(-2.19038924308126298e-01 + 2.38887684293386041e-02 * h0 + 9.93240388032053667e-02 * h1 + -8.02414456798488801e-02 * h2 + -7.42730986305323998e-02 * h3 + 7.14106702956328609e-02 * h4 + -1.12963765186954140e-01 * h5 + 1.06700353669448050e-01 * h6 + -6.45991017827861752e-02 * h7 + -6.69888380433606850e-02 * h8 + -3.46743843246102943e-03 * h9 + -1.28051778780192527e-01 * h10 + -1.28258748704156711e-02 * h11 + 1.83883885870236075e-01 * h12 + 1.49183087857611224e-01 * h13 + -1.48289557578971554e-01 * h14 + -1.73078757465856023e-03 * h15);
    k12 = tanh(2.48402192882166389e-01 + -1.57482077280048482e-01 * h0 + 1.50049443021933682e-01 * h1 + -1.37030695035407157e-01 * h2 + -8.88510765281348286e-02 * h3 + 7.48163579544502445e-03 * h4 + 9.82961488738323813e-02 * h5 + 1.94678680482537309e-01 * h6 + 6.62614199311490765e-02 * h7 + -3.66226903916236912e-02 * h8 + 9.32993919686826018e-03 * h9 + -1.49753077810212548e-01 * h10 + -1.51459254844041637e-02 * h11 + 1.67927815663378416e-01 * h12 + 1.42717066665362935e-01 * h13 + -1.34049312546142135e-01 * h14 + -5.02051373498703726e-03 * h15);
    k13 = tanh(1.28133455406916480e-01 + -2.13703375412502755e-01 * h0 + 1.55505216789375067e-01 * h1 + -1.66203892561284788e-01 * h2 + -2.26729671475970451e-01 * h3 + 1.74258659768940033e-01 * h4 + -8.98349806382850447e-02 * h5 + 6.65925582364386148e-02 * h6 + 1.16606326162381035e-01 * h7 + -2.75704834649442114e-02 * h8 + -8.53192358385993638e-02 * h9 + -2.24835365839720969e-01 * h10 + 1.37463299627148178e-01 * h11 + 6.61248448391165838e-02 * h12 + 2.17213152447315427e-01 * h13 + -9.62272797056181184e-02 * h14 + 9.84408973536496368e-02 * h15);
    k14 = tanh(-1.93475798513815855e-01 + -4.64109417306421898e-02 * h0 + 5.48519492598479666e-02 * h1 + -1.62419862873000975e-01 * h2 + 9.48980358954520410e-03 * h3 + 7.07236751786525508e-02 * h4 + 1.57242291015718891e-02 * h5 + 1.92658831377762567e-02 * h6 + -8.63739399533515056e-02 * h7 + 1.10336476231411559e-01 * h8 + -1.31153284113233959e-01 * h9 + 4.86599060721394985e-02 * h10 + -1.00280388907062770e-01 * h11 + -8.70980414722414137e-02 * h12 + 6.94557449027541629e-02 * h13 + -1.30526611552007316e-01 * h14 + 6.73927037393048101e-02 * h15);
    k15 = tanh(9.10088057325668387e-02 + 3.35268892640688612e-02 * h0 + -1.18979850386401631e-01 * h1 + 5.29574163666761480e-02 * h2 + 1.47450570740473436e-01 * h3 + 9.44122512223381505e-02 * h4 + -5.83022702845903754e-02 * h5 + -1.80012616080000992e-01 * h6 + -2.80595595431492768e-02 * h7 + 1.90590260555115160e-01 * h8 + -9.73252598211720860e-02 * h9 + 1.34845941683954584e-01 * h10 + 1.94517827582367159e-01 * h11 + -1.59257094088417567e-01 * h12 + -2.71471943745760391e-01 * h13 + 1.32306146899657917e-01 * h14 + -3.26966918562473022e-02 * h15);
    acc = -2.62970929271732455e-02 + -5.48152931021629874e-02 * k0 + -5.61975898915282324e-02 * k1 + 1.33252547697530366e-01 * k2 + -7.85297637719775538e-02 * k3 + -7.53773614871831726e-02 * k4 + -2.60417554800445698e-02 * k5 + 9.98697184042106750e-02 * k6 + -1.32505017008950565e-01 * k7 + 8.93963785142305734e-02 * k8 + 4.22647589237358373e-02 * k9 + -9.64782042610329293e-02 * k10 + 6.18246239769929262e-02 * k11 + 3.08227571900813978e-02 * k12 + 7.61125696129879570e-02 * k13 + 6.72750746002267058e-02 * k14 + -1.54552073735316431e-01 * k15;
    gsum = gsum + 1 * tanh(acc);
    I(d, s) <+ (exp(gsum / 1) - 1.0) * ib;
  end
endmodule
