* Standalone 77K typical-corner library (cryo corners + stock mismatch params)
.lib tt_77k
.param mc_mm_switch=0
.param mc_pr_switch=0
.param my_gauss = 0
.param m = 1
.include "out/pdk_ml_final/cards/sky130_fd_pr__nfet_01v8_lvt__tt_77k.corner.spice"
.include "out/pdk_ml_final/cards/sky130_fd_pr__pfet_01v8_lvt__tt_77k.corner.spice"
.include "/Users/anrunw/Documents/cryo-ml/data/raw/pdk/sky130A/libs.ref/sky130_fd_pr/spice/sky130_fd_pr__nfet_01v8_lvt__mismatch.corner.spice"
.include "/Users/anrunw/Documents/cryo-ml/data/raw/pdk/sky130A/libs.ref/sky130_fd_pr/spice/sky130_fd_pr__pfet_01v8_lvt__mismatch.corner.spice"
.endl
